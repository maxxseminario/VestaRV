// ===========================================================================
// npu.rdl: the register map of hdl/common/periph/NPU.vhd (the MMR block at
// the end of the file, decoded off MabMmrAInt).
//
// THE VHDL IS THE AUTHORITY. Slot numbers are MemoryMap.vhd's MmrAddrNPU*
// and everything resets to 0.
//
// NPUTHINK (NPUCR bit 16) is a SEPARATE FLOP, not part of the NPUCR vector:
// byte lane 2 splits around it (`NPUCR(23 downto 17) <= D(23 downto 17);
// NPUTHINK <= D(16)`), the read mux re-inserts it at bit 16, and NpuDone
// clears it. It is therefore a plain read/write bit that hardware also
// clears -- writing 0 to it stops nothing, but it is not write-1-only, which
// is what the generator's rw1 code claims.
// ===========================================================================

`include "vesta_udp.rdl"

enum npucr_npuxpk_e {
    ONE_INPUT_ELEMENT_PER = 1'h0 { desc = "One input element per 32-bit word (reset default)"; };
    TWO_16_BIT_Q0 = 1'h1 { desc = "Two 16-bit Q0.15 input elements per 32-bit word"; };
};
enum npucr_npuwpk_e {
    ONE_WEIGHT_PER_32 = 1'h0 { desc = "One weight per 32-bit word (reset default)"; };
    TWO_16_BIT_Q3 = 1'h1 { desc = "Two 16-bit Q3.12 weights per 32-bit word"; };
};
enum npucr_nputdie_e {
    INTERRUPT_DISABLED_POLLING_ONLY = 1'h0 { desc = "Interrupt disabled (polling only)"; };
    INTERRUPT_ENABLED = 1'h1 { desc = "Interrupt enabled"; };
};
enum npucr_npuben_e {
    DISABLED = 1'h0 { desc = "Disabled"; };
    ENABLED = 1'h1 { desc = "Enabled"; };
};
enum npucr_npuaen_e {
    DISABLED_LINEAR_OUTPUT = 1'h0 { desc = "Disabled (linear output)"; };
    ENABLED_LOGISTIC_SIGMOID_APPROXIMATION = 1'h1 { desc = "Enabled (logistic sigmoid approximation)"; };
};
enum npucr_nputhink_e {
    IDLE_COMPUTATION_COMPLETE_OR = 1'h0 { desc = "Idle (computation complete or not started)"; };
    RUNNING_WRITE_1_TO = 1'h1 { desc = "Running (write 1 to start)"; };
};
enum npusr_nputhinkdone_e {
    NO_COMPLETED_COMPUTATION_PENDING = 1'h0 { desc = "No completed computation pending"; };
    A_COMPUTATION_HAS_COMPLETED = 1'h1 { desc = "A computation has completed"; };
};

// NPUTHINK is a standalone flop written with the raw bit value from lane 2, set by the EVFAB task_think pulse, and cleared by NpuDone.
reg NPUCR_t {
    regwidth = 32;
    desc = "NPU control register";
    field {
        sw = rw; hw = r;
        reset = 1'h0;
        vesta_access = "rw";
        encode = npucr_npuxpk_e;
        desc = "Packed input format enable: when set, the input vector holds two 16-bit Q0.15 elements per staging word (element 2i in bits 15:0, element 2i+1 in bits 31:16), so element i is read from word NPUIVSAR + i/2; when clear each input occupies its own 32-bit word as Q0.24. The setting is latched when NPUTHINK is set and is ignored in XNOR-popcount mode. See the packed operand formats in the functional description.";
    } NPUXPK[27:27];
    field {
        sw = rw; hw = r;
        reset = 1'h0;
        vesta_access = "rw";
        encode = npucr_npuwpk_e;
        desc = "Packed weight format enable: when set, the weight matrix holds two 16-bit Q3.12 weights per staging word (element 2i in bits 15:0, element 2i+1 in bits 31:16) in the same element order as the unpacked layout; when clear each weight occupies its own 32-bit word as Q7.24. The setting is latched when NPUTHINK is set and is ignored in XNOR-popcount mode. See the packed operand formats in the functional description for the range and saturation rules.";
    } NPUWPK[26:26];
    field {
        sw = rw; hw = r;
        reset = 3'h0;
        vesta_access = "rw";
        desc = "Activation function applied to the accumulator output while NPUAEN = 1; with NPUAEN = 0 the raw accumulator passes through regardless of this field. 0 = logistic sigmoid approximation (reset default), output Q0.24 in [0, 1). 1 = ReLU, output Q7.24. 2 = tanh approximation, output in [-1, 1). 3 = clamp to [-1, 1). 4 = exponential approximation 2*sigmoid(x), output Q1.24 in [0, 2). Codes 5-7 are reserved and behave as 0. The selection is latched when NPUTHINK is set; see the activation functions in the functional description for the exact formulas and output formats.";
    } NPUACTF[25:23];
    field {
        sw = rw; hw = r;
        reset = 3'h0;
        vesta_access = "rw";
        desc = "Datapath mode select. 0 = multilayer-perceptron mode (reset default). 1 = one-dimensional convolution mode. 2 = XNOR-popcount binary mode (NPUBEN and NPUAEN must be 0). 3 = general matrix-multiply (GEMM) mode (NPUBEN must be 0). Codes 4-7 are reserved and behave as mode 0. The mode is latched when NPUTHINK is set; see the datapath modes in the functional description for the operand layout of each mode.";
    } NPUMODE[22:20];
    field {
        sw = rw; hw = r;
        reset = 1'h0;
        vesta_access = "rw";
        encode = npucr_nputdie_e;
        desc = "Think-done interrupt enable. When set, NPUSR.NPUTHINKDONE drives the NPU think-done interrupt (vector 120); when clear the flag is available for polling only.";
    } NPUTDIE[19:19];
    field {
        sw = rw; hw = r;
        reset = 1'h0;
        vesta_access = "rw";
        encode = npucr_npuben_e;
        desc = "Bias enable. When set, the first weight of each output neuron's row in the weight matrix is used as a bias term: it is multiplied by an implicit input of 1.0 and accumulated before the synaptic weights.";
    } NPUBEN[18:18];
    field {
        sw = rw; hw = r;
        reset = 1'h0;
        vesta_access = "rw";
        encode = npucr_npuaen_e;
        desc = "Activation function enable. When set, the logistic sigmoid approximation activation function is applied to the accumulator output. When cleared, the raw accumulator output is used (linear/identity).";
    } NPUAEN[17:17];
    field {
        sw = rw; hw = rw;
        reset = 1'h0;
        vesta_access = "rw";
        encode = npucr_nputhink_e;
        desc = "Computation start and busy flag. Writing 1 starts the NPU; the bit reads 1 until the computation completes, when hardware clears it. While it reads 1 the staging RAM belongs to the NPU.";
    } NPUTHINK[16:16];
    field {
        sw = rw; hw = r;
        reset = 8'h0;
        vesta_access = "rw";
        desc = "Number of inputs in the input vector minus 1. The actual number of inputs is NPUNI + 1.";
    } NPUNI[15:8];
    field {
        sw = rw; hw = r;
        reset = 8'h0;
        vesta_access = "rw";
        desc = "Number of output neurons minus 1. The actual number of outputs is NPUNN + 1.";
    } NPUNN[7:0];
};

reg NPUIVSAR_t {
    regwidth = 32;
    desc = "Input vector start word index within the shared NPU staging RAM: the byte offset from the start of the staging RAM (0xC000) divided by 4. For example, an input vector at byte address 0xC100 has word index 0x40. Each input is a signed Q0.24 value stored in bits 24:0 of its 32-bit SRAM word; bits 31:25 are ignored. Bit 24 is the sign bit. The input at index 0 is at word index NPUIVSAR. The input at index 1 is at word index NPUIVSAR + 1. The rest of the inputs follow in consecutive words. This one-input-per-word layout is what NPUCR.NPUXPK = 0 (the reset default) selects; with NPUXPK = 1 the vector is packed two 16-bit Q0.15 inputs per word and input index i is read from word index NPUIVSAR + i/2, low half first.";
    field {
        sw = rw; hw = r;
        reset = 12'h0;
        vesta_access = "rw";
        desc = "Input vector start word index within the NPU staging RAM (byte offset from 0xC000 divided by 4)";
    } NPUIVSAR[11:0];
};

reg NPUWVSAR_t {
    regwidth = 32;
    desc = "Synaptic weight matrix start word index within the shared NPU staging RAM: the byte offset from the start of the staging RAM (0xC000) divided by 4. Each weight is a signed Q7.24 value occupying all 32 bits of its SRAM word; bit 31 is the sign bit. Weights are stored row-major, one per 32-bit word, in the following order: for each output neuron (0 through NPUNN), if bias is enabled (NPUBEN = 1), the first word in the row is the bias weight (multiplied by an implicit input of 1.0), followed by NPUNI + 1 synaptic weights for inputs 0 through NPUNI. If bias is disabled, each row contains NPUNI + 1 synaptic weights only. This one-weight-per-word layout is what NPUCR.NPUWPK = 0 (the reset default) selects; with NPUWPK = 1 the same weight sequence is packed two 16-bit Q3.12 weights per word, low half first, halving the word count of the block.";
    field {
        sw = rw; hw = r;
        reset = 12'h0;
        vesta_access = "rw";
        desc = "Synaptic weight matrix start word index within the NPU staging RAM (byte offset from 0xC000 divided by 4)";
    } NPUWVSAR[11:0];
};

reg NPUOVSAR_t {
    regwidth = 32;
    desc = "Output vector start word index within the shared NPU staging RAM: the byte offset from the start of the staging RAM (0xC000) divided by 4. Each output is a signed Q7.24 value occupying all 32 bits of its SRAM word; bit 31 is the sign bit. The output at index 0 is written to word index NPUOVSAR. The output at index 1 is at word index NPUOVSAR + 1, and so on.";
    field {
        sw = rw; hw = r;
        reset = 12'h0;
        vesta_access = "rw";
        desc = "Output vector start word index within the NPU staging RAM (byte offset from 0xC000 divided by 4)";
    } NPUOVSAR[11:0];
};

reg NPUSR_t {
    regwidth = 32;
    desc = "NPU status register. NPUTHINKDONE is write-1-to-clear and is never cleared by a read; the think-done interrupt (vector 120) is NPUTHINKDONE and NPUCR.NPUTDIE. Clearing NPUTHINKDONE does not affect NPUCR.NPUTHINK, and the staging RAM stays owned by the NPU until NPUCR.NPUTHINK reads 0.";
    // Write-1-to-clear on bit 0, taken on the FREE-RUNNING Clk so a clear cannot be lost while the gated NpuClk is stopped.
    field {
        sw = rw; hw = w; onwrite = woclr;
        reset = 1'h0;
        vesta_access = "rw1";
        encode = npusr_nputhinkdone_e;
        desc = "Think-done flag, set by hardware when a computation finishes (the same event that clears NPUTHINK) and held until software writes 1 to it. It drives the think-done interrupt (vector 120) while NPUTDIE = 1. A completion that coincides with a write of 1 leaves the flag set.";
    } NPUTHINKDONE[0:0];
};

reg NPUCFG1_t {
    regwidth = 32;
    desc = "NPU mode configuration word 1. The interpretation depends on NPUCR.NPUMODE. Multilayer-perceptron mode (0): unused, no effect. One-dimensional convolution mode (1): bits 3:0 = stride S (1-15), bits 7:4 = dilation D (1-15), bits 23:8 = input length L per channel in samples, bits 31:24 = number of input channels minus 1 (the actual channel count Cin is this field + 1). XNOR-popcount mode (2): the full 32-bit signed firing threshold THRESH. A neuron fires (output +1.0) when 2*popcount(XNOR(activations, weights)) - K is greater than or equal to THRESH, else outputs -1.0. GEMM mode (3): bits 7:0 = M - 1, the number of A rows minus 1 (the actual row count M is this field + 1); bits 31:8 are ignored in this mode.";
    field {
        sw = rw; hw = r;
        reset = 32'h0;
        vesta_access = "rw";
        desc = "Per-mode configuration word 1 (interpretation selected by NPUCR.NPUMODE)";
    } NPUCFG1[31:0];
};

reg NPUCFG2_t {
    regwidth = 32;
    desc = "NPU mode configuration word 2. The interpretation depends on NPUCR.NPUMODE. Multilayer-perceptron mode (0): unused, no effect. One-dimensional convolution mode (1): bits 15:0 = output length Lout per filter in samples. Lout is computed by the host (the sequencer trusts this value; the valid/same padding convention is a firmware decision) and every referenced input sample index j*S + k*D must be less than L. XNOR-popcount mode (2): bits 12:0 = K, the exact input bit count (1-4096); NPUNI must hold ceil(K/32) - 1, the packed words per neuron, and when K mod 32 is nonzero the unused high bits of each last packed word are masked out of the popcount by hardware. GEMM mode (3): unused, no effect. Bits 31:16 are reserved and read 0.";
    field {
        sw = rw; hw = r;
        reset = 16'h0;
        vesta_access = "rw";
        desc = "Per-mode configuration word 2 (interpretation selected by NPUCR.NPUMODE)";
    } NPUCFG2[15:0];
};
addrmap npu {
    name = "NPU";
    desc = "Fixed-point multilayer perceptron (MLP) neural network processing unit";
    vesta_peripheral = "NPU";
    vesta_vector = 120;
    vesta_word_base = 0;

    default regwidth = 32;

    NPUCR_t    NPUCR    @0x00;
    NPUIVSAR_t NPUIVSAR @0x04;
    NPUWVSAR_t NPUWVSAR @0x08;
    NPUOVSAR_t NPUOVSAR @0x0C;
    NPUSR_t    NPUSR    @0x10;
    NPUCFG1_t  NPUCFG1  @0x14;
    NPUCFG2_t  NPUCFG2  @0x18;
};
