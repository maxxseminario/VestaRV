// =============================================================================
// afe2.rdl: the register map of one analog front-end site, hdl/common/periph/AFE2.vhd.
//
// THE VHDL IS THE AUTHORITY. Every offset, width, reset value and access type
// here was read out of AFE2.vhd's W_* word constants, its IMPL mask table and its
// RSTVAL table, and //platform/common:rdl_vs_vhdl_afe2_test re-derives all four
// from that file on every build. The prose is the generator's, verbatim, so the
// TRM chapter this description drives is byte-identical to the one generate.py
// emits today (//platform/common:rdl_vs_generator_test).
//
// Four sites at 0x6C00 + 0x100*site, page-2 sub-slots 12-15. Words 9-63 of a
// site's sub-slot hold no flop and read 0, except on SITE 0, where biasg.rdl
// overlays words 9-13 with the shared bias generator's control registers.
// One interrupt vector, 124, shared by the four sites: each site's SR
// demultiplexes it.
//
// Two reset values are NOT zero and both are deliberate:
//   AFExCR.AFESAMPLESTEP = 7   the characterised 400 ns sample phase at 20 MHz
//   AFExMUX.AFEATPSEL    = 0xF the anatop_quad ATP grant is NOT(AND4(ATP_SEL)),
//                              so 0xF parks every site off the shared test pads
// =============================================================================

`include "vesta_udp.rdl"

enum afexcr_afeswapen_e {
    AFESWAPEN_A_DAC_VP_VP = 1'h0 { desc = "A_Dac_Vp = VP"; };
    AFESWAPEN_A_DAC_VP_ALTERNATES = 1'h1 { desc = "A_Dac_Vp alternates VP / VP2"; };
};
enum afexcr_afeen_e {
    AFEEN_CONVERTER_IN_RESET = 1'h0 { desc = "Converter in reset"; };
    AFEEN_CONVERTER_RELEASED = 1'h1 { desc = "Converter released"; };
};

reg AFExCR_t {
    regwidth = 32;
    desc = "Control. EN releases the converter reset (SARADC_rst = not EN) and, after 128 MCLK of quiet, allows a start; START and SYNC are write-1 pulses and read 0. SAMPLESTEP resets to 7 (the characterised 400 ns sample phase at 20 MHz); every other bit resets to 0.";
    field {
        sw = rw; hw = r;
        reset = 4'h0;
        vesta_access = "rw";
        desc = "Trigger-clock divider: SARADC_clk = MCLK / (2 (CLKDIV + 1)). 0 gives 20 MHz from a 40 MHz MCLK (the characterised rate) and 12 MHz from 24 MHz.";
    } AFECLKDIV[15:12];
    field {
        sw = rw; hw = r;
        reset = 4'h7;
        vesta_access = "rw";
        desc = "Extra sample-phase ticks: the sample pulse is 1 + SAMPLESTEP ticks and a conversion is 16 + SAMPLESTEP ticks. Resets to 7.";
    } AFESAMPLESTEP[11:8];
    field {
        sw = rw; hw = r;
        reset = 1'h0;
        vesta_access = "rw";
        encode = afexcr_afeswapen_e;
        desc = "Excitation swap engine: with CONT set, A_Dac_Vp alternates between DACVP.VP and SWAP.VP2 every PERIOD + 1 conversions, switching at a conversion boundary.";
    } AFESWAPEN[7:7];
    field {
        sw = rw; hw = r;
        reset = 1'h0;
        vesta_access = "rw";
        desc = "Interrupt enable for OVF and TO.";
    } AFEERRIE[6:6];
    field {
        sw = rw; hw = r;
        reset = 1'h0;
        vesta_access = "rw";
        desc = "Interrupt enable for DRDY (result FIFO not empty).";
    } AFEDRDYIE[5:5];
    field {
        sw = rw; hw = r;
        reset = 1'h0;
        vesta_access = "rw";
        desc = "Start on the shared trigger: a SYNC written on any site starts every site with SYNCEN set on the same MCLK edge.";
    } AFESYNCEN[4:4];
    field {
        sw = w;  hw = r; singlepulse;
        reset = 1'h0;
        vesta_access = "w1";
        desc = "Broadcast the simultaneous-sample trigger (one MCLK pulse to all four sites). Self-clearing, reads 0.";
    } AFESYNC[3:3];
    field {
        sw = w;  hw = r; singlepulse;
        reset = 1'h0;
        vesta_access = "w1";
        desc = "Start a conversion (a continuous run when CONT is set). Ignored unless REL is set and the site is not BUSY. Self-clearing, reads 0.";
    } AFESTART[2:2];
    field {
        sw = rw; hw = r;
        reset = 1'h0;
        vesta_access = "rw";
        desc = "Continuous conversion: the pattern reloads at every conversion boundary until CONT is cleared, when the conversion in flight completes.";
    } AFECONT[1:1];
    field {
        sw = rw; hw = r;
        reset = 1'h0;
        vesta_access = "rw";
        encode = afexcr_afeen_e;
        desc = "Converter enable. 0 holds SARADC_rst high, stops the trigger clock and aborts a run; 1 releases the reset and starts the 128 MCLK quiet period.";
    } AFEEN[0:0];
};

reg AFExSR_t {
    regwidth = 32;
    desc = "Status. DRDY, OVF and TO take a write-1: DRDY pops the FIFO head, OVF and TO clear. BUSY, REL and CNT are read-only live status.";
    field {
        sw = r;  hw = w;
        reset = 4'h0;
        vesta_access = "r";
        desc = "Result FIFO occupancy, 0 to 4.";
    } AFECNT[11:8];
    field {
        sw = rw; hw = w; onwrite = woclr;
        reset = 1'h0;
        vesta_access = "rw1";
        desc = "Missed READY: no READY inside 2048 MCLK of an aperture, or a new aperture with the previous conversion still outstanding. Write 1 to clear.";
    } AFETO[4:4];
    field {
        sw = r;  hw = w;
        reset = 1'h0;
        vesta_access = "r";
        desc = "Converter released: SARADC_rst low and the quiet period elapsed; START is accepted.";
    } AFEREL[3:3];
    field {
        sw = rw; hw = w; onwrite = woclr;
        reset = 1'h0;
        vesta_access = "rw1";
        desc = "A result arrived with the FIFO full and was dropped. Write 1 to clear.";
    } AFEOVF[2:2];
    field {
        sw = rw; hw = w; onwrite = woclr;
        reset = 1'h0;
        vesta_access = "rw1";
        desc = "Result FIFO not empty (DATA holds the oldest result). Write 1 to pop the head; a pop on an empty FIFO does nothing.";
    } AFEDRDY[1:1];
    field {
        sw = r;  hw = w;
        reset = 1'h0;
        vesta_access = "r";
        desc = "A conversion pattern is running.";
    } AFEBUSY[0:0];
};

reg AFExDATA_t {
    regwidth = 32;
    desc = "Result FIFO head, side-effect-free. Bit 9 of the converter bus is already inverted, so CODE is the straight 10-bit code, offset-binary about the common-mode code. Reads 0 with VALID clear when the FIFO is empty.";
    field {
        sw = r;  hw = w;
        reset = 1'h0;
        vesta_access = "r";
        desc = "The entry is valid (FIFO not empty at the read).";
    } AFEVALID[15:15];
    field {
        sw = r;  hw = w;
        reset = 1'h0;
        vesta_access = "r";
        desc = "Excitation swap phase at this conversion's aperture (0 = VP, 1 = VP2).";
    } AFEPHTAG[14:14];
    field {
        sw = r;  hw = w;
        reset = 4'h0;
        vesta_access = "r";
        desc = "SARADC_SEL (MUX.ADCSEL) at this conversion's aperture.";
    } AFESELTAG[13:10];
    field {
        sw = r;  hw = w;
        reset = 10'h0;
        vesta_access = "r";
        desc = "Converter code, bit 9 corrected (code = raw xor 0x200).";
    } AFECODE[9:0];
};

reg AFExTIA_t {
    regwidth = 32;
    desc = "Transimpedance feedback ladder: Rf = 18 kOhm + 6 kOhm N, N = RESEN + 64 popcount(THEN), 0 to 319. Active-high = insert. Resets to 0 (minimum gain).";
    field {
        sw = rw; hw = r;
        reset = 4'h0;
        vesta_access = "rw";
        desc = "ThEn<3:0>: thermometer segments, 64 units each.";
    } AFETHEN[9:6];
    field {
        sw = rw; hw = r;
        reset = 6'h0;
        vesta_access = "rw";
        desc = "ResEn<5:0>: binary segments (32/16/8/4/2/1 units).";
    } AFERESEN[5:0];
};

reg AFExDACVP_t {
    regwidth = 32;
    desc = "Potential-program DAC (A_Dac_Vp, 610.35 uV per code) and its enable.";
    field {
        sw = rw; hw = r;
        reset = 1'h0;
        vesta_access = "rw";
        desc = "En_Dac_Vp.";
    } AFEVPEN[12:12];
    field {
        sw = rw; hw = r;
        reset = 12'h0;
        vesta_access = "rw";
        desc = "A_Dac_Vp<11:0>, straight binary. With SWAPEN set this is the phase-0 code.";
    } AFEVP[11:0];
};

reg AFExDACVCM_t {
    regwidth = 32;
    desc = "Common-mode DAC (A_Dac_Vcm, 610.35 uV per code) and its enable.";
    field {
        sw = rw; hw = r;
        reset = 1'h0;
        vesta_access = "rw";
        desc = "En_Dac_Vcm.";
    } AFEVCMEN[12:12];
    field {
        sw = rw; hw = r;
        reset = 12'h0;
        vesta_access = "rw";
        desc = "A_Dac_Vcm<11:0>, straight binary.";
    } AFEVCM[11:0];
};

reg AFExBIAS_t {
    regwidth = 32;
    desc = "Local bias generator trim. Higher code = smaller bias current, 2.7 percent per code. Reset 0 is not the nominal trim: load the stored code first in every power-up sequence.";
    field {
        sw = rw; hw = r;
        reset = 6'h0;
        vesta_access = "rw";
        desc = "Bias_Adj<5:0>.";
    } AFEBIASADJ[5:0];
};

reg AFExMUX_t {
    regwidth = 32;
    desc = "Converter input and analog test-port selects. ADCSEL: 0 = TIA output, 1 = common mode, 2 = potential-program DAC, 4 = test port, 5 = ground; other slots are undriven, do not select. ATPSEL slot 0 is undriven at reset.";
    field {
        sw = rw; hw = r;
        reset = 4'hF;
        vesta_access = "rw";
        desc = "ATP_SEL<3:0>: analog test-port multiplexer select.";
    } AFEATPSEL[7:4];
    field {
        sw = rw; hw = r;
        reset = 4'h0;
        vesta_access = "rw";
        desc = "SARADC_SEL<3:0>: converter input multiplexer select. Wait 0.54 us after a change before a result is meaningful.";
    } AFEADCSEL[3:0];
};

reg AFExSWAP_t {
    regwidth = 32;
    desc = "Excitation swap engine: the second potential code and the half period, in conversions. The swap and the converter strobe share one divider, so the excitation grid is commensurate with sampling.";
    field {
        sw = rw; hw = r;
        reset = 16'h0;
        vesta_access = "rw";
        desc = "Half period minus 1, in conversions: A_Dac_Vp toggles every PERIOD + 1 conversions.";
    } AFEPERIOD[31:16];
    field {
        sw = rw; hw = r;
        reset = 12'h0;
        vesta_access = "rw";
        desc = "Phase-1 potential code.";
    } AFEVP2[11:0];
};

addrmap afe2_site {
    name = "AFE2";
    desc = "One analog front-end site: the digital half of one anatop_pixel channel.";
    vesta_peripheral = "AFEx";
    vesta_vector = 124;
    vesta_word_base = 0;

    default regwidth = 32;

    AFExCR_t     AFExCR     @0x00;
    AFExSR_t     AFExSR     @0x04;
    AFExDATA_t   AFExDATA   @0x08;
    AFExTIA_t    AFExTIA    @0x0C;
    AFExDACVP_t  AFExDACVP  @0x10;
    AFExDACVCM_t AFExDACVCM @0x14;
    AFExBIAS_t   AFExBIAS   @0x18;
    AFExMUX_t    AFExMUX    @0x1C;
    AFExSWAP_t   AFExSWAP   @0x20;
};

// The four sites as the chip sees them. Nothing consumes this map today -- the
// emitters work on afe2_site, one description per peripheral TEMPLATE, the way
// generate.py does -- but it is the statement of record that the sites are
// identical and 0x100 apart, and PeakRDL's own exporters render it directly.
addrmap afe2_sites {
    name = "AFE2 sites";
    desc = "The four AFE2 sites, page-2 sub-slots 12-15.";

    afe2_site site[4] @0x6C00 += 0x100;
};
