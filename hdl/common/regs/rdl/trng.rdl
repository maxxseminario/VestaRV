// VestaRV: the register map of hdl/common/periph/TRNG.vhd
// The VHDL is the authority: four slots from the block's SLOT_* constants, all resets zero, every write lane-0 qualified.
// TRNGxDR is the one register in this library with a READ SIDE EFFECT, and the decode is explicit about it: the write case's SLOT_DR arm fires on `if WEn = "1111"`, a READ, and consumes the word when one is valid and not already being retired. A read with no word ready returns 0 and consumes nothing.

`include "vesta_udp.rdl"

enum trngxcr_trngalmie_e {
    INTERRUPT_DISABLED = 1'h0 { desc = "Interrupt disabled"; };
    INTERRUPT_ENABLED = 1'h1 { desc = "Interrupt enabled"; };
};
enum trngxcr_trngdrdyie_e {
    INTERRUPT_DISABLED = 1'h0 { desc = "Interrupt disabled"; };
    INTERRUPT_ENABLED = 1'h1 { desc = "Interrupt enabled"; };
};
enum trngxcr_trngen_e {
    DISABLED_RINGS_PARKED = 1'h0 { desc = "Disabled (rings parked)"; };
    ENABLED = 1'h1 { desc = "Enabled"; };
};
enum trngxsr_trngrun_e {
    IDLE_HALTED = 1'h0 { desc = "Idle / halted"; };
    RUNNING = 1'h1 { desc = "Running"; };
};
enum trngxsr_trngalmf_e {
    NO_ALARM = 1'h0 { desc = "No alarm"; };
    REPETITION_COUNT_CUTOFF_REACHED = 1'h1 { desc = "Repetition-count cutoff reached"; };
};
enum trngxsr_trngdrdy_e {
    NO_WORD_READY_A = 1'h0 { desc = "No word ready (a TRNG0DR read now returns 0 and does not consume)"; };
    WORD_READY = 1'h1 { desc = "Word ready"; };
};

reg TRNGxCR_t {
    regwidth = 32;
    desc = "TRNG control register. EN gates the entropy source (0 parks the RO rings -- the power/leakage lever -- and freezes harvesting; flags and the last assembled word are preserved). DRDYIE/ALMIE independently gate the two halves of the combined interrupt (vector 121). ROSEL selects/masks which rings in the ensemble contribute to the XOR reduction (0000 = all rings, the safe default-on encoding, D6 ruling 4). DECIM sets the decimation: one raw sample is taken every 2^DECIM MCLK cycles (0 = every cycle); a larger DECIM lets more independent ring jitter accumulate between samples. Resets to 0 (disabled).";
    field {
        sw = rw; hw = r;
        reset = 4'h0;
        vesta_access = "rw";
        desc = "Decimation exponent. One raw sample is taken every 2^TRNGDECIM MCLK cycles (0 = every MCLK cycle, up to 32768 cycles at 15). A nonzero value is recommended for real accumulation between independent samples (D7).";
    } TRNGDECIM[11:8];
    field {
        sw = rw; hw = r;
        reset = 4'h0;
        vesta_access = "rw";
        desc = "Ring-oscillator ensemble contribution select/mask, forwarded to the entropy source. 0000 selects every ring in the ensemble (the reset-safe all-on encoding); a nonzero value masks a subset of the NRO rings into the XOR reduction (D6 ruling 4).";
    } TRNGROSEL[7:4];
    field {
        sw = rw; hw = r;
        reset = 1'h0;
        vesta_access = "rw";
        encode = trngxcr_trngalmie_e;
        desc = "Health-alarm interrupt enable. When set, TRNG0SR.ALMF drives the combined interrupt (vector 121).";
    } TRNGALMIE[2:2];
    field {
        sw = rw; hw = r;
        reset = 1'h0;
        vesta_access = "rw";
        encode = trngxcr_trngdrdyie_e;
        desc = "Data-ready interrupt enable. When set, TRNG0SR.DRDY drives the combined interrupt (vector 121).";
    } TRNGDRDYIE[1:1];
    field {
        sw = rw; hw = r;
        reset = 1'h0;
        vesta_access = "rw";
        encode = trngxcr_trngen_e;
        desc = "Entropy engine enable. 0 parks the RO ensemble and freezes the decimator/assembler/health test; the last assembled word, DRDY, and ALMF are preserved. 1 lets the rings oscillate and harvesting proceed (subject to the health-test auto-halt, D8/ruling 3).";
    } TRNGEN[0:0];
};

// Lane-0 write-1-to-clear on ALMF only; DRDY (0) and RUN (2) are read-only.
reg TRNGxSR_t {
    regwidth = 32;
    desc = "TRNG status register. DRDY and RUN are read-only levels; ALMF is a sticky write-1-to-clear health-alarm flag (write a 1 to clear it; writing 0 leaves it unchanged; never cleared by a read; a set arriving the same cycle as a clear survives, D8). DRDY reflects the D9 blind-window-corrected level: a qualifying TRNG0DR read clears DRDY in the SAME cycle as the consuming read (an SR read issued immediately after a DR read observes DRDY=0 even though the harvest engine has not yet finished tearing the word down internally), so polling DRDY right after draining TRNG0DR is always accurate. The combined interrupt (vector 121) is (DRDY and TRNGDRDYIE) or (ALMF and TRNGALMIE).";
    field {
        sw = r; hw = w;
        reset = 1'h0;
        vesta_access = "r";
        encode = trngxsr_trngrun_e;
        desc = "Entropy engine running: TRNGEN is set and no health alarm is currently latched (D12). Reads 0 whenever the rings are parked, either because TRNGEN=0 or because TRNGALMF is set (auto-halt).";
    } TRNGRUN[2:2];
    field {
        sw = rw; hw = w; onwrite = woclr;
        reset = 1'h0;
        vesta_access = "rw1";
        encode = trngxsr_trngalmf_e;
        desc = "Health-test alarm flag (sticky). Set when the repetition-count health test (TRNG0HT.RCTC, or the hardware default of 32) reaches its cutoff; while set, harvesting is AUTO-HALTED (D8/ruling 3: no new sample feeds the assembler, DRDY cannot re-assert, RUN reads 0) -- write 1 to clear and let harvesting resume once the raw stream is healthy again. Drives vector 121 when TRNGALMIE is set. Write 1 to clear.";
    } TRNGALMF[1:1];
    field {
        sw = r; hw = w;
        reset = 1'h0;
        vesta_access = "r";
        encode = trngxsr_trngdrdy_e;
        desc = "Data ready: a fresh 32-bit entropy word is available in TRNG0DR. Clears the SAME cycle as the qualifying TRNG0DR read that consumes the word (D9 blind-window fix), and re-asserts only once the harvest engine assembles the NEXT word.";
    } TRNGDRDY[0:0];
};

reg TRNGxDR_t {
    regwidth = 32;
    desc = "Entropy data register. [31:0] is the most recently assembled 32-bit entropy word, direct-packed MSB-first from decimated ring-oscillator samples (D7, ruling 1: no hardware whitening -- firmware DRBGs the output, D16). READ SIDE EFFECT (D9, the one exception to \"no read side effects\" in this register library): a qualifying read (TRNGDRDY=1 at the time of the access) CONSUMES the word -- TRNG0SR.DRDY clears the SAME cycle, and the harvest engine begins assembling the next word. The consume is gated to fire EXACTLY ONCE per real bus access (a repeated internal edge in the same access cannot double-pop). A read while TRNGDRDY=0 (no word ready, or the previous word is still being retired) returns 0 and does NOT consume anything -- the next real word is still delivered intact on a later read. Writes are ignored.";
    // READ-CONSUME: a qualifying read (TRNGDRDY = 1) returns the word and clears DRDY in the same cycle; the consume is gated by dr_consume_pending so a repeated internal edge inside one access cannot double-pop. A read with DRDY = 0 returns 0 and has no side effect. Writes are ignored.
    field {
        sw = r; hw = w; onread = rclr;
        reset = 32'h0;
        vesta_access = "r";
        desc = "Entropy word. A read while TRNGDRDY=1 returns the word and consumes it (DRDY clears the same cycle, D9); a read while TRNGDRDY=0 returns 0 and does not consume.";
    } TRNGDR[31:0];
};

// Only TRNGRCTC (7:0) is writable; TRNGRUNLEN (21:16) is a read-only saturating diagnostic.
reg TRNGxHT_t {
    regwidth = 32;
    desc = "Health-test control/diagnostic register. RCTC is the repetition-count cutoff: the number of consecutive identical raw samples that trips the alarm (TRNG0SR.ALMF). RCTC=0 selects the hardware default of 32 (ruling 3), so the reset value is a safe default-on cutoff; a nonzero value is a firmware override. RUNLEN is a read-only saturating diagnostic exposing the CURRENT consecutive-identical-sample run length (resets to 1 on any change, saturates at 63) -- useful for tuning RCTC or observing ring health without waiting for an alarm. Other bits reserved, read 0. Resets to 0.";
    field {
        sw = r; hw = w;
        reset = 6'h0;
        vesta_access = "r";
        desc = "Current consecutive-identical-raw-sample run length (0 to 63, saturating diagnostic). Resets to 1 (via have_prev) on the first sample after any change; does not itself trigger the alarm -- compare against TRNGRCTC to see how close the raw stream is to tripping it.";
    } TRNGRUNLEN[21:16];
    field {
        sw = rw; hw = r;
        reset = 8'h0;
        vesta_access = "rw";
        desc = "Repetition-count cutoff (0 to 255). 0 selects the hardware default of 32 consecutive identical raw samples (D8/ruling 3); a nonzero value overrides it.";
    } TRNGRCTC[7:0];
};
addrmap trng {
    name = "TRNGx";
    desc = "Ring-oscillator entropy source and harvest engine: a free-running ensemble of NRO ring oscillators (peripherals.trngRings, {4,8}) is XOR-reduced to one noisy bit, 2-FF synchronized into the free-running MCLK, decimated (one raw sample every 2^DECIM MCLK cycles) and direct-packed 32 raw bits at a time into a holding register";
    vesta_peripheral = "TRNGx";
    vesta_word_base = 0;

    default regwidth = 32;

    TRNGxCR_t TRNGxCR @0x00;
    TRNGxSR_t TRNGxSR @0x04;
    TRNGxDR_t TRNGxDR @0x08;
    TRNGxHT_t TRNGxHT @0x0C;
};
