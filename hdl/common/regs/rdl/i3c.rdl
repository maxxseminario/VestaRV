// ===========================================================================
// i3c.rdl: the register map of hdl/common/periph/I3C.vhd.
//
// THE VHDL IS THE AUTHORITY, and I3CxCR does NOT reset to zero:
// `I3CxCR <= (2 => '1', others => '0')` makes I3CSDAPP the one bit set out
// of reset (push-pull SDA default). The generator models it as 0.
//
// A lane-0 write to I3CxCMD is the sole launch trigger, guarded by
// I3CEN = 1 and BUSY = 0; the DAT window (slots 5-7) is a four-entry table
// indexed by the persisted I3CIDX, and its storage lives in the
// free-running clk domain, not in reg_write.
// ===========================================================================

`include "vesta_udp.rdl"

enum i3cxcr_i3ctxeie_e {
    INTERRUPT_DISABLED = 1'h0 { desc = "Interrupt disabled"; };
    INTERRUPT_ENABLED = 1'h1 { desc = "Interrupt enabled"; };
};
enum i3cxcr_i3crxfie_e {
    INTERRUPT_DISABLED = 1'h0 { desc = "Interrupt disabled"; };
    INTERRUPT_ENABLED = 1'h1 { desc = "Interrupt enabled"; };
};
enum i3cxcr_i3cibiie_e {
    INTERRUPT_DISABLED = 1'h0 { desc = "Interrupt disabled"; };
    INTERRUPT_ENABLED = 1'h1 { desc = "Interrupt enabled"; };
};
enum i3cxcr_i3cdaaie_e {
    INTERRUPT_DISABLED = 1'h0 { desc = "Interrupt disabled"; };
    INTERRUPT_ENABLED = 1'h1 { desc = "Interrupt enabled"; };
};
enum i3cxcr_i3cerrie_e {
    INTERRUPT_DISABLED = 1'h0 { desc = "Interrupt disabled"; };
    INTERRUPT_ENABLED = 1'h1 { desc = "Interrupt enabled"; };
};
enum i3cxcr_i3ctcie_e {
    INTERRUPT_DISABLED = 1'h0 { desc = "Interrupt disabled"; };
    INTERRUPT_ENABLED = 1'h1 { desc = "Interrupt enabled"; };
};
enum i3cxcr_i3cibien_e {
    IBIS_NACKED = 1'h0 { desc = "IBIs NACKed"; };
    IBIS_ACCEPTED = 1'h1 { desc = "IBIs accepted"; };
};
enum i3cxcr_i3csdapp_e {
    FORCE_OPEN_DRAIN = 1'h0 { desc = "Force open-drain"; };
    PUSH_PULL_SDR_DATA = 1'h1 { desc = "Push-pull SDR data"; };
};
enum i3cxcr_i3cbusmode_e {
    I3C_SDR = 1'h0 { desc = "I3C SDR"; };
    LEGACY_I2C = 1'h1 { desc = "Legacy I2C"; };
};
enum i3cxcr_i3cen_e {
    DISABLED_SERIAL_CORE_IN = 1'h0 { desc = "Disabled (serial core in reset)"; };
    ENABLED = 1'h1 { desc = "Enabled"; };
};
enum i3cxcmd_i3cdasa_e {
    NO_SETDASA = 1'h0 { desc = "No SETDASA"; };
    RUN_SETDASA = 1'h1 { desc = "Run SETDASA"; };
};
enum i3cxcmd_i3cdaarun_e {
    NO_ENTDAA = 1'h0 { desc = "No ENTDAA"; };
    RUN_ENTDAA = 1'h1 { desc = "Run ENTDAA"; };
};
enum i3cxcmd_i3ccccdir_e {
    BROADCAST_CCC = 1'h0 { desc = "Broadcast CCC"; };
    DIRECT_CCC = 1'h1 { desc = "Direct CCC"; };
};
enum i3cxcmd_i3cccc_e {
    PRIVATE_TRANSFER = 1'h0 { desc = "Private transfer"; };
    CCC = 1'h1 { desc = "CCC"; };
};
enum i3cxcmd_i3cstopen_e {
    HOLD_THE_BUS_AT = 1'h0 { desc = "Hold the bus at end (for a following repeated START)"; };
    ISSUE_STOP_AT_END = 1'h1 { desc = "Issue STOP at end"; };
};
enum i3cxcmd_i3crepstart_e {
    START = 1'h0 { desc = "START"; };
    REPEATED_START = 1'h1 { desc = "Repeated START"; };
};
enum i3cxcmd_i3crnw_e {
    WRITE_CONTROLLER_DRIVES_I3CXTX = 1'h0 { desc = "Write (controller drives I3CxTX out)"; };
    READ_CONTROLLER_CAPTURES_INTO = 1'h1 { desc = "Read (controller captures into I3CxRX)"; };
};
enum i3cxsr_i3cibiwon_e {
    NO_LIVE_IBI = 1'h0 { desc = "No live IBI"; };
    IBI_IN_ARBITRATION = 1'h1 { desc = "IBI in arbitration"; };
};
enum i3cxsr_i3cibip_e {
    NO_EVENT = 1'h0 { desc = "No event"; };
    IBI_CAPTURED = 1'h1 { desc = "IBI captured"; };
};
enum i3cxsr_i3cdaafull_e {
    NO_EVENT = 1'h0 { desc = "No event"; };
    DAT_ENTRY_CAPTURED = 1'h1 { desc = "DAT entry captured"; };
};
enum i3cxsr_i3cdaadone_e {
    NO_EVENT = 1'h0 { desc = "No event"; };
    DAA_COMPLETE = 1'h1 { desc = "DAA complete"; };
};
enum i3cxsr_i3carblost_e {
    NO_EVENT = 1'h0 { desc = "No event"; };
    ARBITRATION_LOST = 1'h1 { desc = "Arbitration lost"; };
};
enum i3cxsr_i3ceodf_e {
    NO_EVENT = 1'h0 { desc = "No event"; };
    EARLY_END_OF_DATA = 1'h1 { desc = "Early end-of-data"; };
};
enum i3cxsr_i3canack_e {
    NO_EVENT = 1'h0 { desc = "No event"; };
    ADDRESS_BYTE_NACK = 1'h1 { desc = "Address / byte NACK"; };
};
enum i3cxsr_i3ctxeif_e {
    NO_EVENT = 1'h0 { desc = "No event"; };
    TRANSMIT_REGISTER_EMPTY = 1'h1 { desc = "Transmit register empty"; };
};
enum i3cxsr_i3crxfull_e {
    NO_EVENT = 1'h0 { desc = "No event"; };
    RECEIVE_REGISTER_FULL = 1'h1 { desc = "Receive register full"; };
};
enum i3cxsr_i3ctcif_e {
    NO_EVENT = 1'h0 { desc = "No event"; };
    TRANSFER_COMPLETE = 1'h1 { desc = "Transfer complete"; };
};
enum i3cxsr_i3cbusy_e {
    IDLE = 1'h0 { desc = "Idle"; };
    TRANSACTION_IN_PROGRESS = 1'h1 { desc = "Transaction in progress"; };
};
enum i3cxdat_i3cstatvalid_e {
    NO_STATIC_ADDRESS = 1'h0 { desc = "No static address"; };
    STATIC_ADDRESS_PRESENT = 1'h1 { desc = "Static address present"; };
};
enum i3cxdat_i3cdynvalid_e {
    NO_DYNAMIC_ADDRESS = 1'h0 { desc = "No dynamic address"; };
    DYNAMIC_ADDRESS_ASSIGNED = 1'h1 { desc = "Dynamic address assigned"; };
};
enum i3cxdat_i3cevalid_e {
    EMPTY = 1'h0 { desc = "Empty"; };
    VALID = 1'h1 { desc = "Valid"; };
};
enum i3cxibi_i3cibiacked_e {
    NACKED = 1'h0 { desc = "NACKed"; };
    ACKED = 1'h1 { desc = "ACKed"; };
};
enum i3cxibi_i3cibihasdata_e {
    NO_DATA_BYTE = 1'h0 { desc = "No data byte"; };
    I3CIBIMDB_VALID = 1'h1 { desc = "I3CIBIMDB valid"; };
};
enum i3cxibi_i3cibivalid_e {
    EMPTY = 1'h0 { desc = "Empty"; };
    VALID_CAPTURE = 1'h1 { desc = "Valid capture"; };
};

// I3CSDAPP resets to 1 (`I3CxCR <= (2 => '1', others => '0')`). Bits 7:4 are written by lane 0 and read back, so they are RW scratch rather than reserved-zero.
reg I3CxCR_t {
    regwidth = 32;
    desc = "I3C control register. Configures the bus mode, SDA drive style, open-drain and push-pull baud dividers, and the interrupt enables. Reconfigure only while the controller is idle (I3CBUSY = 0); the mode and drive bits are additionally latched at each transaction launch. Resets to 0 except I3CSDAPP, which resets to 1.";
    field {
        sw = rw; hw = r;
        reset = 1'h0;
        vesta_access = "rw";
        encode = i3cxcr_i3ctxeie_e;
        desc = "Transmit-empty interrupt enable (interrupt vector 88).";
    } I3CTXEIE[29:29];
    field {
        sw = rw; hw = r;
        reset = 1'h0;
        vesta_access = "rw";
        encode = i3cxcr_i3crxfie_e;
        desc = "Receive-full interrupt enable (interrupt vector 87).";
    } I3CRXFIE[28:28];
    field {
        sw = rw; hw = r;
        reset = 1'h0;
        vesta_access = "rw";
        encode = i3cxcr_i3cibiie_e;
        desc = "In-band interrupt pending interrupt enable (interrupt vector 93).";
    } I3CIBIIE[27:27];
    field {
        sw = rw; hw = r;
        reset = 1'h0;
        vesta_access = "rw";
        encode = i3cxcr_i3cdaaie_e;
        desc = "Dynamic-address-assignment done interrupt enable (interrupt vector 92).";
    } I3CDAAIE[26:26];
    field {
        sw = rw; hw = r;
        reset = 1'h0;
        vesta_access = "rw";
        encode = i3cxcr_i3cerrie_e;
        desc = "Error interrupt enable: gates the address-NACK (vector 89), early-end-of-data (vector 90), and arbitration-lost (vector 91) sources.";
    } I3CERRIE[25:25];
    field {
        sw = rw; hw = r;
        reset = 1'h0;
        vesta_access = "rw";
        encode = i3cxcr_i3ctcie_e;
        desc = "Transfer-complete interrupt enable (interrupt vector 86).";
    } I3CTCIE[24:24];
    field {
        sw = rw; hw = r;
        reset = 8'h0;
        vesta_access = "rw";
        desc = "Push-pull baud divider. The push-pull SCL rate is SMCLK / (2 * (1 + I3CPPBR)); used for SDR data once the bus is in push-pull. SMCLK is the SYSTEM clock source (write SYS_CLK_CR = 0 to run SMCLK from HFXT before using the controller).";
    } I3CPPBR[23:16];
    field {
        sw = rw; hw = r;
        reset = 8'h0;
        vesta_access = "rw";
        desc = "Open-drain baud divider. The open-drain SCL rate is SMCLK / (2 * (1 + I3CODBR)); used for the arbitrated address header and legacy-I2C phases.";
    } I3CODBR[15:8];
    field {
        sw = rw; hw = r;
        reset = 1'h0;
        vesta_access = "rw";
        encode = i3cxcr_i3cibien_e;
        desc = "In-band interrupt accept enable. When set, the controller ACKs a target-initiated IBI and captures it into I3CxIBI; when clear, IBIs are NACKed.";
    } I3CIBIEN[3:3];
    field {
        sw = rw; hw = r;
        reset = 1'h1;
        vesta_access = "rw";
        encode = i3cxcr_i3csdapp_e;
        desc = "SDA drive style for SDR data, latched at launch (resets to 1). When 0 the data phase is forced open-drain (required for legacy-I2C targets).";
    } I3CSDAPP[2:2];
    field {
        sw = rw; hw = r;
        reset = 1'h0;
        vesta_access = "rw";
        encode = i3cxcr_i3cbusmode_e;
        desc = "Bus mode, latched at launch. Selects the framing for the next transaction.";
    } I3CBUSMODE[1:1];
    field {
        sw = rw; hw = r;
        reset = 1'h0;
        vesta_access = "rw";
        encode = i3cxcr_i3cen_e;
        desc = "Controller enable. When 0 the serial core is held in reset (no transaction launches and the serial pins are released) but the RX register, DAT table, and status flags are preserved. Set to 1 before launching a transaction.";
    } I3CEN[0:0];
};

// LAUNCH: a lane-0 write captures I3CCMD(7:0) and raises i3c_launch when I3CEN = 1 and BUSY = 0.
reg I3CxCMD_t {
    regwidth = 32;
    desc = "I3C command register. Describes the next transaction: target address, direction, START/STOP framing, optional CCC and dynamic-address-assignment operations, and the data length. Writing this register with byte lane 0 asserted LAUNCHES the transaction; the content is always captured, but the launch is suppressed when I3CEN = 0 or I3CBUSY = 1. Program I3CxCR (and, for a write, I3CxTX) first, then write I3CxCMD last. All command and control fields are latched at launch.";
    field {
        sw = rw; hw = r;
        reset = 8'h0;
        vesta_access = "rw";
        desc = "CCC opcode (used when I3CCCC = 1; e.g. 0x07 = ENTDAA).";
    } I3CCCCOP[31:24];
    field {
        sw = rw; hw = r;
        reset = 8'h0;
        vesta_access = "rw";
        desc = "Data length, 0 to 255 bytes. The number of payload bytes the data phase transfers.";
    } I3CDLEN[23:16];
    field {
        sw = rw; hw = r;
        reset = 1'h0;
        vesta_access = "rw";
        encode = i3cxcmd_i3cdasa_e;
        desc = "Run SETDASA (set dynamic address from static address) for the addressed DAT entry.";
    } I3CDASA[13:13];
    field {
        sw = rw; hw = r;
        reset = 1'h0;
        vesta_access = "rw";
        encode = i3cxcmd_i3cdaarun_e;
        desc = "Run ENTDAA dynamic address assignment. When set (with I3CCCC and I3CCCCOP = 0x07), the controller runs the ENTDAA loop, assigning the dynamic addresses programmed in the DAT entries to newly discovered targets.";
    } I3CDAARUN[12:12];
    field {
        sw = rw; hw = r;
        reset = 1'h0;
        vesta_access = "rw";
        encode = i3cxcmd_i3ccccdir_e;
        desc = "CCC direction.";
    } I3CCCCDIR[11:11];
    field {
        sw = rw; hw = r;
        reset = 1'h0;
        vesta_access = "rw";
        encode = i3cxcmd_i3cccc_e;
        desc = "Common Command Code transaction. When set, the transaction is a CCC (0x7E broadcast auto-prepended; the opcode is in I3CCCCOP).";
    } I3CCCC[10:10];
    field {
        sw = rw; hw = r;
        reset = 1'h0;
        vesta_access = "rw";
        encode = i3cxcmd_i3cstopen_e;
        desc = "STOP enable.";
    } I3CSTOPEN[9:9];
    field {
        sw = rw; hw = r;
        reset = 1'h0;
        vesta_access = "rw";
        encode = i3cxcmd_i3crepstart_e;
        desc = "Repeated-START (Sr) entry. When set, the transaction begins with a repeated START instead of a START, chaining onto a bus previously held (see I3CSTOPEN).";
    } I3CREPSTART[8:8];
    field {
        sw = rw; hw = r;
        reset = 1'h0;
        vesta_access = "rw";
        encode = i3cxcmd_i3crnw_e;
        desc = "Direction.";
    } I3CRNW[7:7];
    field {
        sw = rw; hw = r;
        reset = 7'h0;
        vesta_access = "rw";
        desc = "7-bit target address. The broadcast address 0x7E is auto-prepended by hardware only when I3CCCC = 1.";
    } I3CADDR[6:0];
};

reg I3CxTX_t {
    regwidth = 32;
    desc = "I3C transmit data. Writing the low byte arms the per-byte transmit handshake for the data phase; writing this register never launches a transaction (only an I3CxCMD write does). The upper bits are reserved for future word-packing.";
    // A lane-0 write both loads the byte and arms the byte-pending handshake (tx_arm), which is NOT gated on I3CEN: a byte armed before enable survives to be consumed.
    field {
        sw = rw; hw = r;
        reset = 8'h0;
        vesta_access = "rw";
        desc = "Next write byte.";
    } I3CTX[7:0];
};

reg I3CxRX_t {
    regwidth = 32;
    desc = "I3C receive data. The most recently received byte. Reads have NO side effects (reading I3CxRX clears nothing). Reset-cleared to 0.";
    field {
        sw = r; hw = w;
        reset = 8'h0;
        vesta_access = "r";
        desc = "Last received byte.";
    } I3CRX[7:0];
};

// Lane-0 write-1-to-clear on bits 9:1; BUSY (0) and IBIWON (10) are read-only.
reg I3CxSR_t {
    regwidth = 32;
    desc = "I3C status register. I3CBUSY and I3CIBIWON are read-only; the event flags are write-1-to-clear (write a 1 to a bit to clear it; writing 0 leaves it unchanged).";
    field {
        sw = r; hw = w;
        reset = 1'h0;
        vesta_access = "r";
        encode = i3cxsr_i3cibiwon_e;
        desc = "IBI-won (live). Reads 1 while a target is currently winning IBI arbitration on the bus.";
    } I3CIBIWON[10:10];
    field {
        sw = rw; hw = w; onwrite = woclr;
        reset = 1'h0;
        vesta_access = "rw1";
        encode = i3cxsr_i3cibip_e;
        desc = "In-band interrupt pending flag. Set when an accepted IBI has been captured into I3CxIBI; drives vector 93 when I3CIBIIE is set. Write 1 to clear (which also releases the I3CxIBI snapshot).";
    } I3CIBIP[9:9];
    field {
        sw = rw; hw = w; onwrite = woclr;
        reset = 1'h0;
        vesta_access = "rw1";
        encode = i3cxsr_i3cdaafull_e;
        desc = "DAA capture-full flag. Set when a DAA run captured a newly discovered device into a DAT entry. Write 1 to clear.";
    } I3CDAAFULL[8:8];
    field {
        sw = rw; hw = w; onwrite = woclr;
        reset = 1'h0;
        vesta_access = "rw1";
        encode = i3cxsr_i3cdaadone_e;
        desc = "Dynamic-address-assignment done flag. Set when an ENTDAA/SETDASA run completes; drives vector 92 when I3CDAAIE is set. Write 1 to clear.";
    } I3CDAADONE[7:7];
    field {
        sw = rw; hw = w; onwrite = woclr;
        reset = 1'h0;
        vesta_access = "rw1";
        encode = i3cxsr_i3carblost_e;
        desc = "Arbitration-lost flag. Set when the controller loses address-header arbitration; drives vector 91 when I3CERRIE is set. Write 1 to clear.";
    } I3CARBLOST[6:6];
    field {
        sw = rw; hw = w; onwrite = woclr;
        reset = 1'h0;
        vesta_access = "rw1";
        encode = i3cxsr_i3ceodf_e;
        desc = "Early end-of-data flag (read). Set when a target ends a read (T = 0) before I3CDLEN bytes; drives vector 90 when I3CERRIE is set. Write 1 to clear.";
    } I3CEODF[5:5];
    field {
        sw = rw; hw = w; onwrite = woclr;
        reset = 1'h0;
        vesta_access = "rw1";
        encode = i3cxsr_i3canack_e;
        desc = "Address-NACK flag. Set when a target NACKs the address (or a legacy per-byte NACK occurs); drives vector 89 when I3CERRIE is set. Write 1 to clear.";
    } I3CANACK[4:4];
    field {
        sw = rw; hw = w; onwrite = woclr;
        reset = 1'h0;
        vesta_access = "rw1";
        encode = i3cxsr_i3ctxeif_e;
        desc = "Transmit-empty flag. Set when the transmit path has consumed I3CxTX and can accept the next byte; drives vector 88 when I3CTXEIE is set. Write 1 to clear.";
    } I3CTXEIF[3:3];
    field {
        sw = rw; hw = w; onwrite = woclr;
        reset = 1'h0;
        vesta_access = "rw1";
        encode = i3cxsr_i3crxfull_e;
        desc = "Receive-full flag. Set when the data phase captures a fresh byte into I3CxRX; drives vector 87 when I3CRXFIE is set. Write 1 to clear. (Reading I3CxRX does NOT clear it.)";
    } I3CRXFULL[2:2];
    field {
        sw = rw; hw = w; onwrite = woclr;
        reset = 1'h0;
        vesta_access = "rw1";
        encode = i3cxsr_i3ctcif_e;
        desc = "Transfer-complete flag. Set when a transaction finishes; drives vector 86 when I3CTCIE is set. Write 1 to clear.";
    } I3CTCIF[1:1];
    field {
        sw = r; hw = w;
        reset = 1'h0;
        vesta_access = "r";
        encode = i3cxsr_i3cbusy_e;
        desc = "Busy. Reads 1 while a transaction is in progress; an I3CxCMD launch is ignored while this bit is set.";
    } I3CBUSY[0:0];
};

// Window into a FOUR-entry table: a write sets I3CIDX from wdata(2:0) and, for idx < 4, that entry's address fields. Reading with I3CIDX >= 4 returns the index alone.
reg I3CxDAT_t {
    regwidth = 32;
    desc = "Device Address Table window. I3CIDX selects which of the 4 DAT entries this window (and I3CxDATPID / I3CxDATINFO) addresses; the index persists across accesses. Each entry holds a target's dynamic address, static address, and validity bits used by DAA and by private transfers.";
    field {
        sw = rw; hw = r;
        reset = 1'h0;
        vesta_access = "rw";
        encode = i3cxdat_i3cstatvalid_e;
        desc = "Static address valid.";
    } I3CSTATVALID[19:19];
    field {
        sw = rw; hw = r;
        reset = 7'h0;
        vesta_access = "rw";
        desc = "Static (legacy-I2C) address (7-bit) of this device, used by SETDASA.";
    } I3CSTATADDR[18:12];
    field {
        sw = rw; hw = r;
        reset = 1'h0;
        vesta_access = "rw";
        encode = i3cxdat_i3cdynvalid_e;
        desc = "Dynamic address valid.";
    } I3CDYNVALID[11:11];
    field {
        sw = rw; hw = r;
        reset = 7'h0;
        vesta_access = "rw";
        desc = "Dynamic address (7-bit) assigned to (or to assign to) this device.";
    } I3CDYNADDR[10:4];
    field {
        sw = rw; hw = r;
        reset = 1'h0;
        vesta_access = "rw";
        encode = i3cxdat_i3cevalid_e;
        desc = "Entry valid. Marks the selected DAT entry as populated.";
    } I3CEVALID[3:3];
    field {
        sw = rw; hw = r;
        reset = 3'h0;
        vesta_access = "rw";
        desc = "DAT entry index (0 to 3; the upper values are ignored). Selects the entry for this register, I3CxDATPID, and I3CxDATINFO.";
    } I3CIDX[2:0];
};

reg I3CxDATPID_t {
    regwidth = 32;
    desc = "Provisional ID (low 32 bits) of the DAT entry selected by I3CIDX. During ENTDAA the controller captures the discovered device's 48-bit PID; software reads it here (and the high 16 bits from I3CxDATINFO) to identify the device.";
    // Reads and writes the entry selected by the persisted I3CIDX; idx >= 4 reads 0 and drops the write.
    field {
        sw = rw; hw = r;
        reset = 32'h0;
        vesta_access = "rw";
        desc = "Provisional ID bits 31:0.";
    } I3CPIDLO[31:0];
};

// Reads and writes the entry selected by the persisted I3CIDX; idx >= 4 reads 0 and drops the write.
reg I3CxDATINFO_t {
    regwidth = 32;
    desc = "High provisional-ID bits and the bus/device characteristic registers of the DAT entry selected by I3CIDX.";
    field {
        sw = rw; hw = r;
        reset = 8'h0;
        vesta_access = "rw";
        desc = "Device Characteristic Register of the device (device type code).";
    } I3CDCR[31:24];
    field {
        sw = rw; hw = r;
        reset = 8'h0;
        vesta_access = "rw";
        desc = "Bus Characteristic Register of the device. BCR bit 2 = 1 indicates the device's IBIs carry a mandatory data byte (captured into I3CIBIMDB).";
    } I3CBCR[23:16];
    field {
        sw = rw; hw = r;
        reset = 16'h0;
        vesta_access = "rw";
        desc = "Provisional ID bits 47:32.";
    } I3CPIDHI[15:0];
};

reg I3CxIBI_t {
    regwidth = 32;
    desc = "In-band interrupt capture. A read-only snapshot of the most recently accepted IBI: which target raised it, its optional mandatory data byte, and whether it was ACKed. The snapshot is held until the I3CIBIP flag is cleared (write 1 to I3CIBIP in I3CxSR).";
    field {
        sw = r; hw = w;
        reset = 1'h0;
        vesta_access = "r";
        encode = i3cxibi_i3cibiacked_e;
        desc = "IBI ACK result.";
    } I3CIBIACKED[17:17];
    field {
        sw = r; hw = w;
        reset = 1'h0;
        vesta_access = "r";
        encode = i3cxibi_i3cibihasdata_e;
        desc = "Mandatory-data-byte present.";
    } I3CIBIHASDATA[16:16];
    field {
        sw = r; hw = w;
        reset = 8'h0;
        vesta_access = "r";
        desc = "Mandatory data byte, when the device's BCR bit 2 = 1 (see I3CIBIHASDATA).";
    } I3CIBIMDB[15:8];
    field {
        sw = r; hw = w;
        reset = 1'h0;
        vesta_access = "r";
        encode = i3cxibi_i3cibivalid_e;
        desc = "IBI snapshot valid.";
    } I3CIBIVALID[7:7];
    field {
        sw = r; hw = w;
        reset = 7'h0;
        vesta_access = "r";
        desc = "Dynamic address of the target that raised the IBI.";
    } I3CIBIADDR[6:0];
};
addrmap i3c {
    name = "I3Cx";
    desc = "I3C controller (MIPI I3C basic, single-controller)";
    vesta_peripheral = "I3Cx";
    vesta_word_base = 0;

    default regwidth = 32;

    I3CxCR_t      I3CxCR      @0x00;
    I3CxCMD_t     I3CxCMD     @0x04;
    I3CxTX_t      I3CxTX      @0x08;
    I3CxRX_t      I3CxRX      @0x0C;
    I3CxSR_t      I3CxSR      @0x10;
    I3CxDAT_t     I3CxDAT     @0x14;
    I3CxDATPID_t  I3CxDATPID  @0x18;
    I3CxDATINFO_t I3CxDATINFO @0x1C;
    I3CxIBI_t     I3CxIBI     @0x20;
};
