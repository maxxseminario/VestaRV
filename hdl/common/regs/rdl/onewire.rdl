// VestaRV: the register map of hdl/common/periph/OneWire.vhd
// The VHDL is the authority: seven slots from the block's SLOT_* constants, every write lane-0 qualified, all resets zero. OWxSPU (slot 6) is reserved: it reads 0 and ignores writes.
// An OWxCMD write is the launch: it captures the descriptor (op, bit value, and a SNAPSHOT of OWODS and OWxTX at write time) and flips launch_tgl when OWEN = 1 and the engine is not busy. An OWxTX write never launches.

`include "vesta_udp.rdl"

enum owxcr_owerrie_e {
    INTERRUPT_DISABLED = 1'h0 { desc = "Interrupt disabled"; };
    INTERRUPT_ENABLED = 1'h1 { desc = "Interrupt enabled"; };
};
enum owxcr_owtcie_e {
    INTERRUPT_DISABLED = 1'h0 { desc = "Interrupt disabled"; };
    INTERRUPT_ENABLED = 1'h1 { desc = "Interrupt enabled"; };
};
enum owxcr_owspuen_e {
    NO_EFFECT = 1'h0 { desc = "No effect"; };
    NO_EFFECT_RESERVED = 1'h1 { desc = "No effect (reserved)"; };
};
enum owxcr_owods_e {
    STANDARD_SPEED = 1'h0 { desc = "Standard speed"; };
    OVERDRIVE_SPEED = 1'h1 { desc = "Overdrive speed"; };
};
enum owxcr_owen_e {
    DISABLED_FSM_IDLE_LAUNCH = 1'h0 { desc = "Disabled (FSM idle, launch suppressed)"; };
    ENABLED = 1'h1 { desc = "Enabled"; };
};
enum owxcmd_owbitval_e {
    WRITE_A_0_BIT = 1'h0 { desc = "Write a 0 bit"; };
    WRITE_A_1_BIT = 1'h1 { desc = "Write a 1 bit"; };
};
enum owxsr_owshort_e {
    NO_ERROR = 1'h0 { desc = "No error"; };
    BUS_STUCK_LOW = 1'h1 { desc = "Bus stuck low"; };
};
enum owxsr_ownopres_e {
    NO_ERROR = 1'h0 { desc = "No error"; };
    NO_PRESENCE_PULSE = 1'h1 { desc = "No presence pulse"; };
};
enum owxsr_owpres_e {
    NO_DEVICE_NOT_YET = 1'h0 { desc = "No device / not yet reset"; };
    DEVICE_PRESENT = 1'h1 { desc = "Device present"; };
};
enum owxsr_owtcif_e {
    NO_EVENT = 1'h0 { desc = "No event"; };
    TRANSACTION_COMPLETE = 1'h1 { desc = "Transaction complete"; };
};
enum owxsr_owbusy_e {
    IDLE = 1'h0 { desc = "Idle"; };
    BUSY = 1'h1 { desc = "Busy"; };
};

reg OWxCR_t {
    regwidth = 32;
    desc = "1-Wire control register. Enables the master (OWEN), selects the bus speed (ODS: standard or overdrive, latched into the transaction descriptor at launch so a mid-flight change never glitches a running slot), holds the transaction-complete and error interrupt enables (TCIE, ERRIE), and carries the reserved strong-pullup enable stub (SPUEN, no effect this stage). Resets to 0 (master idle). The reserved upper bits reserve a future strong-pullup window and timing fields.";
    field {
        sw = rw; hw = r;
        reset = 1'h0;
        vesta_access = "rw";
        encode = owxcr_owerrie_e;
        desc = "Error interrupt enable. When set, OW0SR.NOPRES or OW0SR.SHORT drives the combined 1-Wire interrupt (vector 117).";
    } OWERRIE[4:4];
    field {
        sw = rw; hw = r;
        reset = 1'h0;
        vesta_access = "rw";
        encode = owxcr_owtcie_e;
        desc = "Transaction-complete interrupt enable. When set, OW0SR.TCIF drives the combined 1-Wire interrupt (vector 117).";
    } OWTCIE[3:3];
    field {
        sw = rw; hw = r;
        reset = 1'h0;
        vesta_access = "rw";
        encode = owxcr_owspuen_e;
        desc = "Strong-pullup enable (reserved stub, D15). Writable but inert this stage: there is no driven-high strong-pullup phase (DQ is open-drain, never driven high). Reserved so a future parasite-power SPU bolts on without a register-map break.";
    } OWSPUEN[2:2];
    field {
        sw = rw; hw = r;
        reset = 1'h0;
        vesta_access = "rw";
        encode = owxcr_owods_e;
        desc = "Overdrive speed select, latched into the transaction descriptor at launch. 0 selects the standard slot-timing set, 1 the overdrive (~10x faster) set. (Named ODS; supersedes the spec sketch ODEN, adjudication A2.)";
    } OWODS[1:1];
    field {
        sw = rw; hw = r;
        reset = 1'h0;
        vesta_access = "rw";
        encode = owxcr_owen_e;
        desc = "Master enable. When 0 the slot FSM is held idle and an OW0CMD launch is suppressed (the descriptor is still captured); RX and the status flags are preserved. Set to 1 to run transactions.";
    } OWEN[0:0];
};

// LAUNCH: captures op, bit value, the current OWODS and the current OWxTX byte, then flips launch_tgl when OWEN = 1 and busy = 0. The content is captured launch or no launch.
reg OWxCMD_t {
    regwidth = 32;
    desc = "1-Wire command register. A byte-lane-0 write LAUNCHES a transaction (D8): it always captures {OP, BITVAL, current ODS, current OW0TX byte} into the launch descriptor, and starts the slot FSM unless OWEN=0 or the master is busy (in which case the content is captured but no bus activity or completion occurs). OP selects the primitive (reset / write-bit / read-bit / write-byte / read-byte); BITVAL is the write-bit value. A read returns the last-written OP and BITVAL. Bytes are transmitted/received LSB-first.";
    field {
        sw = rw; hw = r;
        reset = 1'h0;
        vesta_access = "rw";
        encode = owxcmd_owbitval_e;
        desc = "Write-bit value for OP = write-bit (latched at launch; ignored by the other operations).";
    } OWBITVAL[8:8];
    field {
        sw = rw; hw = r;
        reset = 3'h0;
        vesta_access = "rw";
        desc = "Operation: 000 = reset+presence, 001 = write-bit, 010 = read-bit, 011 = write-byte (OW0TX, LSB-first), 100 = read-byte (into OW0RX, LSB-first); 101-111 reserved (no bus activity, no launch).";
    } OWOP[2:0];
};

reg OWxTX_t {
    regwidth = 32;
    desc = "Next write byte, the write-byte (OP = 011) source, transmitted LSB-first. Writing this register never launches a transaction (D8); the byte is sampled into the descriptor at the next OW0CMD launch.";
    // A TX write never launches; the byte is snapshotted into the descriptor by the next OWxCMD write.
    field {
        sw = rw; hw = r;
        reset = 8'h0;
        vesta_access = "rw";
        desc = "Write byte (0 to 255).";
    } OWTX[7:0];
};

reg OWxRX_t {
    regwidth = 32;
    desc = "Last received data (read-only, side-effect-free, A3): a read-byte (OP = 100) assembles into [7:0] LSB-first; a read-bit (OP = 010) lands in [0]. Reset-cleared to 0; a read never clears or launches anything.";
    field {
        sw = r; hw = w;
        reset = 8'h0;
        vesta_access = "r";
        desc = "Received byte (read-byte) or received bit in [0] (read-bit).";
    } OWRX[7:0];
};

reg OWxDIV_t {
    regwidth = 32;
    desc = "Time-base divisor. The slot FSM counts ticks; one tick is (OW0DIV + 1) MCLK cycles. Program OW0DIV = 11 for a 0.5 microsecond tick at 24 MHz MCLK (adjudication A1: all slot counts are integer half-microsecond ticks); a bench uses a small divisor to compress simulation time. Resets to 0.";
    field {
        sw = rw; hw = r;
        reset = 16'h0;
        vesta_access = "rw";
        desc = "Time-base divisor (0 to 65535); tick period = OW0DIV + 1 MCLK cycles.";
    } OWDIV[15:0];
};

// Lane-0 write-1-to-clear on TCIF, NOPRES and SHORT; BUSY (0) and PRES (2) are read-only. BUSY reads the RAW clk-domain level ORed with launch_pending, so a poll right after a launch is never stale-idle.
reg OWxSR_t {
    regwidth = 32;
    desc = "1-Wire status register. BUSY and PRES are read-only levels; TCIF, NOPRES and SHORT are sticky write-1-to-clear flags (write a 1 to a bit to clear it; writing 0 leaves it unchanged; never cleared by a read; a set arriving the same cycle as a clear survives). BUSY covers the launch instant (it reads 1 the same cycle as the launching OW0CMD write, A6), so firmware may poll BUSY-clear immediately after CMD; observe the single-outstanding-transaction rule (poll BUSY before the next CMD). The combined interrupt (vector 117) is (TCIF and TCIE) or ((NOPRES or SHORT) and ERRIE). On a stuck-low bus SHORT wins and NOPRES is suppressed (A5).";
    field {
        sw = rw; hw = w; onwrite = woclr;
        reset = 1'h0;
        vesta_access = "rw1";
        encode = owxsr_owshort_e;
        desc = "Bus-short error. Set when DQ is still low at the end of a recovery window (bus stuck/short) after the master has released it. On a reset, SHORT wins over NOPRES (A5). Drives vector 117 when ERRIE is set. Write 1 to clear.";
    } OWSHORT[4:4];
    field {
        sw = rw; hw = w; onwrite = woclr;
        reset = 1'h0;
        vesta_access = "rw1";
        encode = owxsr_ownopres_e;
        desc = "No-presence error. Set when the last reset saw no presence pulse (clean high release, no device); suppressed if SHORT sets on the same reset (A5). Drives vector 117 when ERRIE is set. Write 1 to clear.";
    } OWNOPRES[3:3];
    field {
        sw = r; hw = w;
        reset = 1'h0;
        vesta_access = "r";
        encode = owxsr_owpres_e;
        desc = "Presence detected. Set when a device answered the last reset with a presence pulse (updated per reset transaction).";
    } OWPRES[2:2];
    field {
        sw = rw; hw = w; onwrite = woclr;
        reset = 1'h0;
        vesta_access = "rw1";
        encode = owxsr_owtcif_e;
        desc = "Transaction-complete flag. Set when the current transaction finishes; drives vector 117 when TCIE is set. Write 1 to clear.";
    } OWTCIF[1:1];
    field {
        sw = r; hw = w;
        reset = 1'h0;
        vesta_access = "r";
        encode = owxsr_owbusy_e;
        desc = "Transaction in progress. An OW0CMD launch is ignored while set. Reads 1 from the cycle of the launching write until completion (A6).";
    } OWBUSY[0:0];
};

// Reserved slot: reads 0, writes ignored.
reg OWxSPU_t {
    regwidth = 32;
    desc = "Reserved for the strong-pullup / parasite-power stage (D15). Reads 0, writes ignored. The slot and the OW0CR.SPUEN field are reserved so a future driven-high strong-pullup (with its bounded firmware-armed safety window) bolts on without a register-map break.";
    field {
        sw = r;  hw = na;
        reset = 32'h0;
        desc = "Reserved.";
    } RESERVED[31:0];
};
addrmap onewire {
    name = "OWx";
    desc = "1-Wire Master: a Dallas/Maxim 1-Wire link-layer controller that runs the five microsecond-scale bus primitives in hardware (reset+presence, write-bit, read-bit, write-byte and read-byte) off a programmable time base, leaving ROM search and CRC-8 to firmware over those primitives";
    vesta_peripheral = "OWx";
    vesta_word_base = 0;

    default regwidth = 32;

    OWxCR_t  OWxCR  @0x00;
    OWxCMD_t OWxCMD @0x04;
    OWxTX_t  OWxTX  @0x08;
    OWxRX_t  OWxRX  @0x0C;
    OWxDIV_t OWxDIV @0x10;
    OWxSR_t  OWxSR  @0x14;
    OWxSPU_t OWxSPU @0x18;
};
