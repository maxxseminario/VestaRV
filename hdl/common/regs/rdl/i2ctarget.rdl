// ===========================================================================
// i2ctarget.rdl: the register map of hdl/common/periph/I2CTarget.vhd.
//
// THE VHDL IS THE AUTHORITY: five slots from the block's SLOT_* constants,
// every write lane-0 qualified, all resets zero.
//
// An I2CTxTX write both loads the buffer and LAUNCHES (payload before flag:
// the byte is captured, then tx_load_tgl flips), and the SR read masks TXE
// with tx_load_pending so a poll immediately after that write never sees a
// stale empty.
// ===========================================================================

`include "vesta_udp.rdl"

enum i2ctxcr_i2ctdataie_e {
    INTERRUPT_DISABLED = 1'h0 { desc = "Interrupt disabled"; };
    INTERRUPT_ENABLED = 1'h1 { desc = "Interrupt enabled"; };
};
enum i2ctxcr_i2ctaeie_e {
    INTERRUPT_DISABLED = 1'h0 { desc = "Interrupt disabled"; };
    INTERRUPT_ENABLED = 1'h1 { desc = "Interrupt enabled"; };
};
enum i2ctxcr_i2ctcsen_e {
    NO_CLOCK_STRETCHING = 1'h0 { desc = "No clock stretching"; };
    CLOCK_STRETCHING_ENABLED = 1'h1 { desc = "Clock stretching enabled"; };
};
enum i2ctxcr_i2ctgcen_e {
    GENERAL_CALL_IGNORED = 1'h0 { desc = "General call ignored"; };
    GENERAL_CALL_ANSWERED = 1'h1 { desc = "General call answered"; };
};
enum i2ctxcr_i2cten_e {
    DISABLED_FSM_IDLE_BUS = 1'h0 { desc = "Disabled (FSM idle, bus released)"; };
    ENABLED = 1'h1 { desc = "Enabled"; };
};
enum i2ctxsr_i2cterrf_e {
    NO_ERROR = 1'h0 { desc = "No error"; };
    PROTOCOL_ERROR_WATCHDOG_TIMEOUT = 1'h1 { desc = "Protocol error / watchdog timeout"; };
};
enum i2ctxsr_i2ctrstartf_e {
    NO_EVENT = 1'h0 { desc = "No event"; };
    REPEATED_START_DETECTED = 1'h1 { desc = "Repeated-START detected"; };
};
enum i2ctxsr_i2ctstopf_e {
    NO_EVENT = 1'h0 { desc = "No event"; };
    STOP_DETECTED = 1'h1 { desc = "STOP detected"; };
};
enum i2ctxsr_i2ctnackf_e {
    NO_EVENT = 1'h0 { desc = "No event"; };
    NACK_HANDSHAKE = 1'h1 { desc = "NACK handshake"; };
};
enum i2ctxsr_i2ctovf_e {
    NO_OVERRUN = 1'h0 { desc = "No overrun"; };
    RX_OVERRUN = 1'h1 { desc = "RX overrun"; };
};
enum i2ctxsr_i2cttxe_e {
    BYTE_LOADED_NOT_TRANSMITTING = 1'h0 { desc = "Byte loaded / not transmitting"; };
    LOAD_I2CTTX = 1'h1 { desc = "Load I2CTTX"; };
};
enum i2ctxsr_i2ctrxf_e {
    BUFFER_EMPTY = 1'h0 { desc = "Buffer empty"; };
    BYTE_AVAILABLE = 1'h1 { desc = "Byte available"; };
};
enum i2ctxsr_i2ctgcf_e {
    NO_EVENT = 1'h0 { desc = "No event"; };
    GENERAL_CALL_MATCHED = 1'h1 { desc = "General call matched"; };
};
enum i2ctxsr_i2ctamf_e {
    NO_EVENT = 1'h0 { desc = "No event"; };
    ADDRESS_MATCHED = 1'h1 { desc = "Address matched"; };
};
enum i2ctxsr_i2cttm_e {
    TARGET_RECEIVER_HOST_WRITE = 1'h0 { desc = "Target-receiver (host write)"; };
    TARGET_TRANSMITTER_HOST_READ = 1'h1 { desc = "Target-transmitter (host read)"; };
};
enum i2ctxsr_i2ctbusy_e {
    BUS_IDLE = 1'h0 { desc = "Bus idle"; };
    TRANSACTION_IN_PROGRESS = 1'h1 { desc = "Transaction in progress"; };
};

reg I2CTxCR_t {
    regwidth = 32;
    desc = "I2C target control register. Enables the target (EN), the general-call response (GCEN), and hardware clock stretching (CSEN); holds the two interrupt enables (AEIE for the address/error IRQ at vector 122, DATAIE for the tx-ready/rx-full IRQ at vector 123); and carries the 7-bit target address (SAD) with a per-bit wildcard mask (SADM, a 1 makes that address bit dont-care). Resets to 0 (target idle, SDA/SCL released).";
    field {
        sw = rw; hw = r;
        reset = 7'h0;
        vesta_access = "rw";
        desc = "Address match mask: a 1 in a bit position makes the corresponding SAD address bit a wildcard (dont-care) during the match.";
    } I2CTSADM[22:16];
    field {
        sw = rw; hw = r;
        reset = 7'h0;
        vesta_access = "rw";
        desc = "7-bit target address matched against the incoming address byte (masked by SADM).";
    } I2CTSAD[14:8];
    field {
        sw = rw; hw = r;
        reset = 1'h0;
        vesta_access = "rw";
        encode = i2ctxcr_i2ctdataie_e;
        desc = "Data interrupt enable. When set, the OR of RXF and TXE drives the combined interrupt at vector 123.";
    } I2CTDATAIE[4:4];
    field {
        sw = rw; hw = r;
        reset = 1'h0;
        vesta_access = "rw";
        encode = i2ctxcr_i2ctaeie_e;
        desc = "Address/error interrupt enable. When set, the OR of the address/error status flags (AMF, GCF, OVF, NACKF, STOPF, RSTARTF, ERRF) drives the combined interrupt at vector 122.";
    } I2CTAEIE[3:3];
    field {
        sw = rw; hw = r;
        reset = 1'h0;
        vesta_access = "rw";
        encode = i2ctxcr_i2ctcsen_e;
        desc = "Clock-stretch enable. When set, the target holds SCL low after an ACK until firmware services the transfer (reads I2CTRX / writes I2CTTX), giving lossless flow control. When 0 the target never stretches; firmware must service within one bit-time or accept an RX overrun / a stale 0xFF transmit byte.";
    } I2CTCSEN[2:2];
    field {
        sw = rw; hw = r;
        reset = 1'h0;
        vesta_access = "rw";
        encode = i2ctxcr_i2ctgcen_e;
        desc = "General-call enable. When set, the target also matches the general-call address (0x00, write direction) and sets GCF alongside AMF.";
    } I2CTGCEN[1:1];
    field {
        sw = rw; hw = r;
        reset = 1'h0;
        vesta_access = "rw";
        encode = i2ctxcr_i2cten_e;
        desc = "Target enable. When 0 the FSM is held idle with SDA/SCL released; the received byte and the status flags are preserved. Set to 1 to respond on the bus.";
    } I2CTEN[0:0];
};

// Lane-0 write-1-to-clear on bits 10:6, 4, 3 and 2; BUSY (0), TM (1) and TXE (5) are read-only. TXE reads masked by tx_load_pending.
reg I2CTxSR_t {
    regwidth = 32;
    desc = "I2C target status register. BUSY, TM and TXE are read-only levels; AMF, GCF, RXF, OVF, NACKF, STOPF, RSTARTF and ERRF are sticky write-1-to-clear event flags (write a 1 to a bit to clear it; writing 0 leaves it unchanged; never cleared by a read; a set arriving the same cycle as a clear survives). The address/error interrupt (vector 122) is (AMF or GCF or OVF or NACKF or STOPF or RSTARTF or ERRF) and AEIE; the data interrupt (vector 123) is (RXF or TXE) and DATAIE.";
    field {
        sw = rw; hw = w; onwrite = woclr;
        reset = 1'h0;
        vesta_access = "rw1";
        encode = i2ctxsr_i2cterrf_e;
        desc = "Error flag: a protocol error or the SCL-low watchdog timeout (I2CTWDG). On expiry the transaction is aborted and BUSY drops. Write 1 to clear.";
    } I2CTERRF[10:10];
    field {
        sw = rw; hw = w; onwrite = woclr;
        reset = 1'h0;
        vesta_access = "rw1";
        encode = i2ctxsr_i2ctrstartf_e;
        desc = "Repeated-START flag: a repeated-START was detected (START while BUSY); the target re-enters the address phase without dropping BUSY. Write 1 to clear.";
    } I2CTRSTARTF[9:9];
    field {
        sw = rw; hw = w; onwrite = woclr;
        reset = 1'h0;
        vesta_access = "rw1";
        encode = i2ctxsr_i2ctstopf_e;
        desc = "STOP flag: a STOP condition was detected. Write 1 to clear.";
    } I2CTSTOPF[8:8];
    field {
        sw = rw; hw = w; onwrite = woclr;
        reset = 1'h0;
        vesta_access = "rw1";
        encode = i2ctxsr_i2ctnackf_e;
        desc = "NACK flag: the host NACKed a transmitted byte (normal read termination), or the target auto-NACKed a received byte on overrun (disambiguate with TM/OVF). Write 1 to clear.";
    } I2CTNACKF[7:7];
    field {
        sw = rw; hw = w; onwrite = woclr;
        reset = 1'h0;
        vesta_access = "rw1";
        encode = i2ctxsr_i2ctovf_e;
        desc = "Receive-overrun flag: a byte arrived while RXF was still set (previous byte unread); the target auto-NACKed and dropped the byte. Write 1 to clear.";
    } I2CTOVF[6:6];
    field {
        sw = r; hw = w;
        reset = 1'h0;
        vesta_access = "r";
        encode = i2ctxsr_i2cttxe_e;
        desc = "Transmit-empty level: asserted while the target is in transmit mode and needs the next byte loaded into I2CTTX. Reads clear (0) in the same cycle as the I2CTTX write that loads a byte (BUSY-same-cycle rule).";
    } I2CTTXE[5:5];
    field {
        sw = rw; hw = w; onwrite = woclr;
        reset = 1'h0;
        vesta_access = "rw1";
        encode = i2ctxsr_i2ctrxf_e;
        desc = "Receive-full flag: a received byte is available in I2CTRX. Read I2CTRX (side-effect-free) then write 1 here to free the buffer. Write 1 to clear.";
    } I2CTRXF[4:4];
    field {
        sw = rw; hw = w; onwrite = woclr;
        reset = 1'h0;
        vesta_access = "rw1";
        encode = i2ctxsr_i2ctgcf_e;
        desc = "General-call flag: the general-call address matched (set alongside AMF when GCEN is set). Write 1 to clear.";
    } I2CTGCF[3:3];
    field {
        sw = rw; hw = w; onwrite = woclr;
        reset = 1'h0;
        vesta_access = "rw1";
        encode = i2ctxsr_i2ctamf_e;
        desc = "Address-match flag: our address (masked) matched this transaction. Write 1 to clear.";
    } I2CTAMF[2:2];
    field {
        sw = r; hw = w;
        reset = 1'h0;
        vesta_access = "r";
        encode = i2ctxsr_i2cttm_e;
        desc = "Transfer direction (latched R/W from the matched address). 1 = target-transmitter (host read); 0 = target-receiver (host write).";
    } I2CTTM[1:1];
    field {
        sw = r; hw = w;
        reset = 1'h0;
        vesta_access = "r";
        encode = i2ctxsr_i2ctbusy_e;
        desc = "Bus busy: set on START, cleared on STOP or a watchdog abort. Distinguishes an initial START from a repeated-START.";
    } I2CTBUSY[0:0];
};

reg I2CTxTX_t {
    regwidth = 32;
    desc = "Transmit byte buffer. A byte-lane-0 write loads the next transmit byte and clears TXE (the loaded byte is shifted out MSB-first on the next host read). Reads back the last-written value.";
    // A lane-0 write loads the byte AND flips tx_load_tgl, arming the target's transmit path.
    field {
        sw = rw; hw = r;
        reset = 8'h0;
        vesta_access = "rw";
        desc = "Next transmit byte (0 to 255).";
    } I2CTTX[7:0];
};

reg I2CTxRX_t {
    regwidth = 32;
    desc = "Last received byte (read-only, side-effect-free, D9): the most recent host-written byte, valid while RXF is set. A read never clears RXF (write 1 to I2CTSR.RXF to free the buffer). Reset 0.";
    field {
        sw = r; hw = w;
        reset = 8'h0;
        vesta_access = "r";
        desc = "Received byte.";
    } I2CTRX[7:0];
};

reg I2CTxWDG_t {
    regwidth = 32;
    desc = "SCL-low watchdog timeout. A counter increments while SCL is held low and the bus is busy; on reaching WDTO x 256 MCLK cycles it sets ERRF, aborts the transaction and drops BUSY. WDTO = 0 disables the watchdog (the reset value, so the default is off, which is identity-safe). The counter resets on every SCL rising edge and when not busy, so a healthy idle bus never trips it.";
    field {
        sw = rw; hw = r;
        reset = 16'h0;
        vesta_access = "rw";
        desc = "SCL-low watchdog timeout in units of 256 MCLK cycles (0 to 65535); 0 disables the watchdog.";
    } I2CTWDTO[15:0];
};
addrmap i2ctarget {
    name = "I2CTx";
    desc = "Hardware-Autonomous I2C Target: an I2C slave engine that handles the protocol in hardware: 7-bit address match with a wildcard mask and optional general-call response, byte-at-a-time receive and transmit with ready/empty status, hardware clock stretching for lossless flow control, START / STOP / repeated-START / NACK framing detection, and a configurable stuck-SCL watchdog";
    vesta_peripheral = "I2CTx";
    vesta_word_base = 0;

    default regwidth = 32;

    I2CTxCR_t  I2CTxCR  @0x00;
    I2CTxSR_t  I2CTxSR  @0x04;
    I2CTxTX_t  I2CTxTX  @0x08;
    I2CTxRX_t  I2CTxRX  @0x0C;
    I2CTxWDG_t I2CTxWDG @0x10;
};
