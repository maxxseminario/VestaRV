// ===========================================================================
// irq_router.rdl: the register map of hdl/common/irq_router.vhd.
//
// THE VHDL IS THE AUTHORITY. The enable rows are 4 words per hart at 4*h,
// the fourth (HhENX) existing only because NUM_SRCS (124 in this
// configuration) exceeds 96; NUM_EN_WORDS = ceil(NUM_SRCS/32) = 4 and the live
// width of the top word is NUM_SRCS - 96 = 28 bits.
//
// PARAMETERISED (report R7). Four routing words per hart, and the live MSB of
// the U and X words follows the interrupt count:
//
//     NHARTS   the hart count (1..32); one four-word row per hart
//     VECTORS  NUM_SRCS, the interrupt source count
//     UMSB     live MSB of the U words = 31 when VECTORS >= 96, else VECTORS-65
//     UTOP     top vector the U words cover = min(VECTORS, 96) - 1
//     XMSB     live MSB of the X words = VECTORS - 97
//
// Two SHAPES cannot be a parameter, because SystemRDL has no conditional
// instantiation and no conditional string, so they are preprocessor guards
// that generate.py defines. Both are ABSENT for every configuration this
// generator emits today (the vector floor is 114), and the sense is chosen so
// that a bare compile of this file is the default five-hart chip:
//
//     VESTA_IRQR_NO_XWORDS   VECTORS <= 96: no HhENX / PENDX / INSVCX at all
//     VESTA_IRQR_U_NARROW    VECTORS <  96: the U words are UMSB:0, not 31:0,
//                            and their prose states the narrower range
//
// CLAIM (word 512, 0x7800) IS NOT A REGISTER: a READ atomically returns the
// lowest pending source ID enabled for the READING hart -- attributed by the
// arbiter's granted master, not by any field -- and sets in_service(id);
// with nothing pending it returns CLAIM_NONE = 0xFFFFFFFF. A WRITE is
// COMPLETE: it clears in_service(id), is owner-unqualified, and ignores IDs
// at or above NUM_SRCS. It holds no flop of its own, so it has no reset
// value in the ordinary sense.
//
// The CLINT source IDs (83 msip, 84 mtip) have writable row bits that are
// INERT: they are delivered per hart on hardwired wires and never routed
// through meip or claim.
// ===========================================================================

`include "vesta_udp.rdl"

reg HENL_t {
    regwidth = 32;
    vesta_name = "H{i}ENL";
    desc = "Hart {i} interrupt routing register, vectors 31:0. Each bit enables delivery of the corresponding interrupt vector to hart {i} via its meip wire (vector 85) and the CLAIM/COMPLETE mechanism.";
    field {
        sw = rw; hw = r;
        reset = 32'h0;
        vesta_access = "rw";
        vesta_name = "IRQRH{i}ENL";
        desc = "Interrupt enable bits for vectors 31:0, routed to hart {i}.";
    } IRQRHENL[31:0];
};

reg HENM_t {
    regwidth = 32;
    vesta_name = "H{i}ENM";
    desc = "Hart {i} interrupt routing register, vectors 63:32.";
    field {
        sw = rw; hw = r;
        reset = 32'h0;
        vesta_access = "rw";
        vesta_name = "IRQRH{i}ENM";
        desc = "Interrupt enable bits for vectors 63:32, routed to hart {i}.";
    } IRQRHENM[31:0];
};

reg HENU_t #(longint unsigned UMSB = 31) {
    regwidth = 32;
    vesta_name = "H{i}ENU";
`ifdef VESTA_IRQR_U_NARROW
    desc = "Hart {i} interrupt routing register, vectors {UTOP}:64 (bits {UMSB}:0; bits 31:{UMSB+1} read as 0). Bits 19 and 20 correspond to the CLINT vectors 83 and 84, which are delivered on dedicated hardwired wires and never through meip: these two bits are writable but have no effect.";
`else
    desc = "Hart {i} interrupt routing register, vectors 95:64. Bits 19 and 20 correspond to the CLINT vectors 83 and 84, which are delivered on dedicated hardwired wires and never through meip: these two bits are writable but have no effect.";
`endif
    field {
        sw = rw; hw = r;
        reset = 0;
        vesta_access = "rw";
        vesta_name = "IRQRH{i}ENU";
`ifdef VESTA_IRQR_U_NARROW
        desc = "Interrupt enable bits for vectors {UTOP}:64, routed to hart {i}.";
`else
        desc = "Interrupt enable bits for vectors 95:64, routed to hart {i}.";
`endif
    } IRQRHENU[UMSB:0];
};

`ifndef VESTA_IRQR_NO_XWORDS
reg HENX_t #(longint unsigned XMSB = 27) {
    regwidth = 32;
    vesta_name = "H{i}ENX";
    desc = "Hart {i} interrupt routing register, vectors {VECTORS-1}:96 (bits {XMSB}:0; upper bits read as 0).";
    field {
        sw = rw; hw = r;
        reset = 0;
        vesta_access = "rw";
        vesta_name = "IRQRH{i}ENX";
        desc = "Interrupt enable bits for vectors {VECTORS-1}:96, routed to hart {i}.";
    } IRQRHENX[XMSB:0];
};
`endif

// One hart's routing row: four consecutive words at 4*h, whether or not the
// fourth is implemented (the slot is reserved either way, as it was before the
// X words existed).
regfile HEN_t #(longint unsigned UMSB = 31, longint unsigned XMSB = 27) {
    HENL_t                HENL @0x0;
    HENM_t                HENM @0x4;
    HENU_t #(.UMSB(UMSB)) HENU @0x8;
`ifndef VESTA_IRQR_NO_XWORDS
    HENX_t #(.XMSB(XMSB)) HENX @0xC;
`endif
};

reg CLAIM_t {
    regwidth = 32;
    desc = "Interrupt claim/complete register (M19). READ = claim: atomically returns the lowest pending interrupt vector that is enabled in the READING hart's routing row and not already under service, and marks it under service (masking it from every hart's meip). Returns 0xFFFFFFFF if nothing is pending for the reader; a handler seeing that value treats the interrupt as spurious and simply returns. WRITE = complete: write the claimed vector number to end its service; the vector becomes deliverable again (and pends immediately if its level is still asserted, so clear the level at the peripheral BEFORE completing). Completion is deliberately not qualified by owner, so a supervisor hart can complete on behalf of a hung hart (recovery); written values that are not valid vector numbers, including a stored 0xFFFFFFFF, are ignored.";
    // READ = claim (side effect: sets in_service on the returned ID; returns 0xFFFFFFFF when nothing is pending). WRITE = complete (clears in_service on the written ID; IDs >= NUM_SRCS are a no-op). No storage.
    field {
        sw = rw; hw = rw;
        reset = 32'h0;
        vesta_access = "rw";
        desc = "Read: claimed vector number (0xFFFFFFFF = none pending for this hart). Write: vector number to complete.";
    } IRQRCLAIM[31:0];
};

reg PENDL_t {
    regwidth = 32;
    desc = "Raw pending interrupt levels, vectors 31:0 (read-only; deglitched peripheral levels before enable/claim masking). Debug and polling aid.";
    // Read-only raw deglitched source levels; bits above NUM_SRCS-1 read 0.
    field {
        sw = r; hw = w;
        reset = 32'h0;
        vesta_access = "r";
        desc = "Deglitched interrupt levels for vectors 31:0.";
    } IRQRPENDL[31:0];
};

reg PENDM_t {
    regwidth = 32;
    desc = "Raw pending interrupt levels, vectors 63:32 (read-only).";
    // Read-only raw deglitched source levels; bits above NUM_SRCS-1 read 0.
    field {
        sw = r; hw = w;
        reset = 32'h0;
        vesta_access = "r";
        desc = "Deglitched interrupt levels for vectors 63:32.";
    } IRQRPENDM[31:0];
};

reg PENDU_t #(longint unsigned UMSB = 31) {
    regwidth = 32;
`ifdef VESTA_IRQR_U_NARROW
    desc = "Raw pending interrupt levels, vectors {UTOP}:64 (bits {UMSB}:0, read-only; bits 31:{UMSB+1} read as 0).";
`else
    desc = "Raw pending interrupt levels, vectors 95:64 (read-only).";
`endif
    // Read-only raw deglitched source levels; bits above NUM_SRCS-1 read 0.
    field {
        sw = r; hw = w;
        reset = 0;
        vesta_access = "r";
`ifdef VESTA_IRQR_U_NARROW
        desc = "Deglitched interrupt levels for vectors {UTOP}:64.";
`else
        desc = "Deglitched interrupt levels for vectors 95:64.";
`endif
    } IRQRPENDU[UMSB:0];
};

`ifndef VESTA_IRQR_NO_XWORDS
reg PENDX_t #(longint unsigned XMSB = 27) {
    regwidth = 32;
    desc = "Raw pending interrupt levels, vectors {VECTORS-1}:96 (bits {XMSB}:0, read-only; upper bits read as 0). Completes the raw-level readback for the fourth enable word (added with the peripheral-library program; before it, sources above 95 were routable and claimable but absent from the debug readback).";
    // Read-only raw deglitched source levels; bits above NUM_SRCS-1 read 0.
    field {
        sw = r; hw = w;
        reset = 0;
        vesta_access = "r";
        desc = "Deglitched interrupt levels for vectors {VECTORS-1}:96.";
    } IRQRPENDX[XMSB:0];
};
`endif

reg INSVCL_t {
    regwidth = 32;
    desc = "Under-service (claimed, not yet completed) flags, vectors 31:0 (read-only). Debug and recovery visibility: a stuck bit here means a hart claimed the vector and never completed it; any hart can recover by writing the vector number to CLAIM.";
    // Read-only in_service bits; a source leaves every hart's meip while its bit is set.
    field {
        sw = r; hw = w;
        reset = 32'h0;
        vesta_access = "r";
        desc = "Under-service flags for vectors 31:0.";
    } IRQRINSVCL[31:0];
};

reg INSVCM_t {
    regwidth = 32;
    desc = "Under-service flags, vectors 63:32 (read-only).";
    // Read-only in_service bits; a source leaves every hart's meip while its bit is set.
    field {
        sw = r; hw = w;
        reset = 32'h0;
        vesta_access = "r";
        desc = "Under-service flags for vectors 63:32.";
    } IRQRINSVCM[31:0];
};

reg INSVCU_t #(longint unsigned UMSB = 31) {
    regwidth = 32;
`ifdef VESTA_IRQR_U_NARROW
    desc = "Under-service flags, vectors {UTOP}:64 (bits {UMSB}:0, read-only; bits 31:{UMSB+1} read as 0).";
`else
    desc = "Under-service flags, vectors 95:64 (read-only).";
`endif
    // Read-only in_service bits; a source leaves every hart's meip while its bit is set.
    field {
        sw = r; hw = w;
        reset = 0;
        vesta_access = "r";
`ifdef VESTA_IRQR_U_NARROW
        desc = "Under-service flags for vectors {UTOP}:64.";
`else
        desc = "Under-service flags for vectors 95:64.";
`endif
    } IRQRINSVCU[UMSB:0];
};

`ifndef VESTA_IRQR_NO_XWORDS
reg INSVCX_t #(longint unsigned XMSB = 27) {
    regwidth = 32;
    desc = "Under-service flags, vectors {VECTORS-1}:96 (bits {XMSB}:0, read-only; upper bits read as 0). Completes the under-service readback for the fourth enable word.";
    // Read-only in_service bits; a source leaves every hart's meip while its bit is set.
    field {
        sw = r; hw = w;
        reset = 0;
        vesta_access = "r";
        desc = "Under-service flags for vectors {VECTORS-1}:96.";
    } IRQRINSVCX[XMSB:0];
};
`endif

addrmap irq_router #(
    longint unsigned NHARTS  = 5,
    longint unsigned VECTORS = 124,
    longint unsigned UMSB    = 31,
    longint unsigned UTOP    = 95,
    longint unsigned XMSB    = 27
) {
    name = "IRQROUTER";
    desc = "THE peripheral interrupt controller (M19): per-hart interrupt routing/enable rows plus a claim/complete delivery stage, programmable by any hart through the shared window";
    vesta_peripheral = "IRQROUTER";
    vesta_word_base = 0;
    vesta_indexed = true;

    default regwidth = 32;

    HEN_t #(.UMSB(UMSB), .XMSB(XMSB)) HEN[NHARTS] @0x000 += 0x10;

    CLAIM_t                 CLAIM  @0x800;
    PENDL_t                 PENDL  @0x810;
    PENDM_t                 PENDM  @0x814;
    PENDU_t #(.UMSB(UMSB))  PENDU  @0x818;
`ifndef VESTA_IRQR_NO_XWORDS
    PENDX_t #(.XMSB(XMSB))  PENDX  @0x81C;
`endif
    INSVCL_t                INSVCL @0x820;
    INSVCM_t                INSVCM @0x824;
    INSVCU_t #(.UMSB(UMSB)) INSVCU @0x828;
`ifndef VESTA_IRQR_NO_XWORDS
    INSVCX_t #(.XMSB(XMSB)) INSVCX @0x82C;
`endif
};
