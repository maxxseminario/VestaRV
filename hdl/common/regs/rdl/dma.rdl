// ===========================================================================
// dma.rdl: the register map of hdl/common/periph/DMA.vhd.
//
// THE VHDL IS THE AUTHORITY. Three things it says that the generator's
// register table does not:
//   DMAxCRC resets to 0xFFFF (`crc_acc <= X"FFFF"`), not 0. The register's
//     own prose already says so; only the reset column disagrees.
//   DMAxCnSRC / DMAxCnDST / DMAxCnLEN are FULL 32-bit stores and full 32-bit
//     readbacks (`src_reg(ch) <= wdata`, `rdata_out <= src_reg(ch)`), so
//     bits 31:17 are writable scratch, not reserved-zero. Out-of-window and
//     misaligned values are rejected at GO with CHnERR rather than masked.
//   DMAxCR.DMAGO and DMAxCR.DMAABORT are write-1 command strobes that read 0
//     (they are absent from the CR read mux), not read/write bits.
//
// Every write in the block is byte-lane-0 qualified, so software uses
// full-word stores. DMAxDESC (slot 19) is reserved: reads 0, writes ignored.
//
// DMAGO and DMAABORT are written sw=w without `singlepulse`: SystemRDL 2.0
// restricts singlepulse to a ONE-BIT field, and both are four bits wide.
// ===========================================================================

`include "vesta_udp.rdl"

enum dmaxcr_dmaerrie_e {
    INTERRUPT_DISABLED = 1'h0 { desc = "Interrupt disabled"; };
    INTERRUPT_ENABLED = 1'h1 { desc = "Interrupt enabled"; };
};
enum dmaxcr_dmadoneie_e {
    INTERRUPT_DISABLED = 1'h0 { desc = "Interrupt disabled"; };
    INTERRUPT_ENABLED = 1'h1 { desc = "Interrupt enabled"; };
};
enum dmaxcr_dmaen_e {
    DISABLED = 1'h0 { desc = "Disabled"; };
    ENABLED = 1'h1 { desc = "Enabled"; };
};
enum dmaxsr_dmabusy_e {
    IDLE = 1'h0 { desc = "Idle"; };
    BUSY = 1'h1 { desc = "Busy"; };
};
enum dmaxc0cfg_dmac0crcen_e {
    NO_CRC = 1'h0 { desc = "No CRC"; };
    ACCUMULATE_CRC = 1'h1 { desc = "Accumulate CRC"; };
};
enum dmaxc0cfg_dmac0prio_e {
    LOW_PRIORITY_CLASS = 1'h0 { desc = "Low priority class"; };
    HIGH_PRIORITY_CLASS = 1'h1 { desc = "High priority class"; };
};
enum dmaxc0cfg_dmac0trig_e {
    SOFTWARE_MEM_TO_MEM = 4'h0 { desc = "Software / mem-to-mem"; };
    UART0_RECEIVE_COMPLETE = 4'h1 { desc = "UART0 receive-complete"; };
    QSPI0_RX_FULL = 4'h2 { desc = "QSPI0 RX-full"; };
    NFC0_PAYLOAD_READY = 4'h3 { desc = "NFC0 payload-ready"; };
};
enum dmaxc0cfg_dmac0dinc_e {
    FIXED_DESTINATION = 1'h0 { desc = "Fixed destination"; };
    INCREMENT_DESTINATION = 1'h1 { desc = "Increment destination"; };
};
enum dmaxc0cfg_dmac0sinc_e {
    FIXED_SOURCE = 1'h0 { desc = "Fixed source"; };
    INCREMENT_SOURCE = 1'h1 { desc = "Increment source"; };
};
enum dmaxc1cfg_dmac1crcen_e {
    NO_CRC = 1'h0 { desc = "No CRC"; };
    ACCUMULATE_CRC = 1'h1 { desc = "Accumulate CRC"; };
};
enum dmaxc1cfg_dmac1prio_e {
    LOW_PRIORITY_CLASS = 1'h0 { desc = "Low priority class"; };
    HIGH_PRIORITY_CLASS = 1'h1 { desc = "High priority class"; };
};
enum dmaxc1cfg_dmac1trig_e {
    SOFTWARE_MEM_TO_MEM = 4'h0 { desc = "Software / mem-to-mem"; };
    UART0_RECEIVE_COMPLETE = 4'h1 { desc = "UART0 receive-complete"; };
    QSPI0_RX_FULL = 4'h2 { desc = "QSPI0 RX-full"; };
    NFC0_PAYLOAD_READY = 4'h3 { desc = "NFC0 payload-ready"; };
};
enum dmaxc1cfg_dmac1dinc_e {
    FIXED_DESTINATION = 1'h0 { desc = "Fixed destination"; };
    INCREMENT_DESTINATION = 1'h1 { desc = "Increment destination"; };
};
enum dmaxc1cfg_dmac1sinc_e {
    FIXED_SOURCE = 1'h0 { desc = "Fixed source"; };
    INCREMENT_SOURCE = 1'h1 { desc = "Increment source"; };
};
enum dmaxc2cfg_dmac2crcen_e {
    NO_CRC = 1'h0 { desc = "No CRC"; };
    ACCUMULATE_CRC = 1'h1 { desc = "Accumulate CRC"; };
};
enum dmaxc2cfg_dmac2prio_e {
    LOW_PRIORITY_CLASS = 1'h0 { desc = "Low priority class"; };
    HIGH_PRIORITY_CLASS = 1'h1 { desc = "High priority class"; };
};
enum dmaxc2cfg_dmac2trig_e {
    SOFTWARE_MEM_TO_MEM = 4'h0 { desc = "Software / mem-to-mem"; };
    UART0_RECEIVE_COMPLETE = 4'h1 { desc = "UART0 receive-complete"; };
    QSPI0_RX_FULL = 4'h2 { desc = "QSPI0 RX-full"; };
    NFC0_PAYLOAD_READY = 4'h3 { desc = "NFC0 payload-ready"; };
};
enum dmaxc2cfg_dmac2dinc_e {
    FIXED_DESTINATION = 1'h0 { desc = "Fixed destination"; };
    INCREMENT_DESTINATION = 1'h1 { desc = "Increment destination"; };
};
enum dmaxc2cfg_dmac2sinc_e {
    FIXED_SOURCE = 1'h0 { desc = "Fixed source"; };
    INCREMENT_SOURCE = 1'h1 { desc = "Increment source"; };
};
enum dmaxc3cfg_dmac3crcen_e {
    NO_CRC = 1'h0 { desc = "No CRC"; };
    ACCUMULATE_CRC = 1'h1 { desc = "Accumulate CRC"; };
};
enum dmaxc3cfg_dmac3prio_e {
    LOW_PRIORITY_CLASS = 1'h0 { desc = "Low priority class"; };
    HIGH_PRIORITY_CLASS = 1'h1 { desc = "High priority class"; };
};
enum dmaxc3cfg_dmac3trig_e {
    SOFTWARE_MEM_TO_MEM = 4'h0 { desc = "Software / mem-to-mem"; };
    UART0_RECEIVE_COMPLETE = 4'h1 { desc = "UART0 receive-complete"; };
    QSPI0_RX_FULL = 4'h2 { desc = "QSPI0 RX-full"; };
    NFC0_PAYLOAD_READY = 4'h3 { desc = "NFC0 payload-ready"; };
};
enum dmaxc3cfg_dmac3dinc_e {
    FIXED_DESTINATION = 1'h0 { desc = "Fixed destination"; };
    INCREMENT_DESTINATION = 1'h1 { desc = "Increment destination"; };
};
enum dmaxc3cfg_dmac3sinc_e {
    FIXED_SOURCE = 1'h0 { desc = "Fixed source"; };
    INCREMENT_SOURCE = 1'h1 { desc = "Increment source"; };
};

// DMAGO and DMAABORT are self-clearing command strobes: the CR read mux returns `errie & doneie & "00000000000" & dmaen`, so both fields read 0. A GO is suppressed while DMAEN = 0 or that channel is busy; an ABORT is always accepted.
reg DMAxCR_t {
    regwidth = 32;
    desc = "DMA control register. Holds the master enable (DMAEN), the per-channel arm/launch and orderly-abort command strobes (CHnGO / CHnABORT, self-clearing, read 0), and the two interrupt enables (DONEIE / ERRIE). Resets to 0. A byte-lane-0 write setting CHnGO[n] captures the channel n {SRC,DST,LEN,CFG} into the working registers and launches it (the launch is suppressed while DMAEN=0 or channel n is already busy). CHnGO/CHnABORT bits for n >= NCH read 0 and ignore writes.";
    field {
        sw = rw; hw = r;
        reset = 1'h0;
        vesta_access = "rw";
        encode = dmaxcr_dmaerrie_e;
        desc = "Error interrupt enable. When set, DMA0SR.CHnERR (OR over channels) drives the DMA0_ERR interrupt (vector 119).";
    } DMAERRIE[13:13];
    field {
        sw = rw; hw = r;
        reset = 1'h0;
        vesta_access = "rw";
        encode = dmaxcr_dmadoneie_e;
        desc = "Combined-done interrupt enable. When set, DMA0SR.CHnDONE (OR over channels) drives the DMA0_DONE interrupt (vector 118).";
    } DMADONEIE[12:12];
    field {
        sw = w; hw = r;
        reset = 4'h0;
        vesta_access = "w";
        desc = "Per-channel orderly-abort command (CHnABORT[3:0], bit 5+n = channel n). Write 1 to request channel n stop; any in-flight arbiter transaction completes normally (the handshake is never truncated), then the channel's busy drops WITHOUT setting CHnDONE or CHnERR (abort is neither done nor error, D15). Self-clearing command (reads 0). Bits for n >= NCH read 0 / ignore writes.";
    } DMAABORT[8:5];
    field {
        sw = w; hw = r;
        reset = 4'h0;
        vesta_access = "w";
        desc = "Per-channel arm+launch command (CHnGO[3:0], bit 1+n = channel n). Write 1 to a bit to capture that channel's programmed descriptor and start the transfer; self-clearing command (reads 0, D8). The launch is suppressed while DMAEN=0 or that channel is busy. Bits for n >= NCH read 0 / ignore writes.";
    } DMAGO[4:1];
    field {
        sw = rw; hw = r;
        reset = 1'h0;
        vesta_access = "rw";
        encode = dmaxcr_dmaen_e;
        desc = "Master enable. When 0 all channels are held idle and every CHnGO launch is suppressed. Set to 1 before arming a channel.";
    } DMAEN[0:0];
};

// Lane-0 write-1-to-clear on CHnDONE and CHnERR; BUSY and ACTIVECH are read-only. The engine's SET wins a same-cycle clear.
reg DMAxSR_t {
    regwidth = 32;
    desc = "DMA status register. BUSY and ACTIVECH are read-only; CHnDONE and CHnERR are sticky write-1-to-clear event flags (write a 1 to a bit to clear it; writing 0 leaves it unchanged; never cleared by a read; a set arriving the same cycle as a clear survives). BUSY asserts the SAME cycle as the triggering CHnGO write (busy OR a GO pending, D8/D16), so a driver may write GO then immediately spin on BUSY. DMA0_DONE (vector 118) = (OR of CHnDONE) and CR.DONEIE; DMA0_ERR (vector 119) = (OR of CHnERR) and CR.ERRIE, both combinational. CHnDONE/CHnERR/ACTIVECH bits for n >= NCH read 0.";
    field {
        sw = r; hw = w;
        reset = 3'h0;
        vesta_access = "r";
        desc = "Index of the currently-serviced channel (0 when idle, engine-set, D16).";
    } DMAACTIVECH[11:9];
    field {
        sw = rw; hw = w; onwrite = woclr;
        reset = 4'h0;
        vesta_access = "rw1";
        desc = "Per-channel error flags (CHnERR[3:0], bit 5+n = channel n). Set on a deny-guard hit, LEN=0 at GO, misaligned/out-of-window/TCM-hole SRC or DST (D13/A18); drives vector 119 when ERRIE is set. Write 1 to clear. Bits for n >= NCH read 0.";
    } DMAERR[8:5];
    field {
        sw = rw; hw = w; onwrite = woclr;
        reset = 4'h0;
        vesta_access = "rw1";
        desc = "Per-channel done flags (CHnDONE[3:0], bit 1+n = channel n). Set when channel n reaches LEN=0 (clean completion); drives vector 118 when DONEIE is set. Write 1 to clear. Bits for n >= NCH read 0.";
    } DMADONE[4:1];
    field {
        sw = r; hw = w;
        reset = 1'h0;
        vesta_access = "r";
        encode = dmaxsr_dmabusy_e;
        desc = "Any channel active OR a GO pending. Asserts the same cycle as the CHnGO write and stays high through real engine activity (no blind window, D8).";
    } DMABUSY[0:0];
};

reg DMAxC0SRC_t {
    regwidth = 32;
    desc = "Channel 0 source byte address in the 0x0-0x1FFFF shared window (word-aligned: bits[1:0] must be 0; bits[31:17] must be 0). The full written 32-bit value reads back; the engine presents byte_ptr(16:2) as the 15-bit arbiter word address. A misaligned, out-of-window (>= 0x20000), or TCM-hole (0x8000-0xBFFF) SRC is rejected at GO with CHnERR (D13/A18).";
    // Full 32-bit store and readback; bits 31:17 are writable scratch. An out-of-window (>= 0x20000), misaligned or TCM-hole address is rejected at GO with CHnERR.
    field {
        sw = rw; hw = r;
        reset = 32'h0;
        vesta_access = "rw";
        desc = "Source byte address (word-aligned).";
    } DMAC0SRC[31:0];
};

reg DMAxC0DST_t {
    regwidth = 32;
    desc = "Channel 0 destination byte address (same word-aligned / in-window / TCM-hole rules as C0SRC, D13/A18).";
    // Full 32-bit store and readback; bits 31:17 are writable scratch. An out-of-window (>= 0x20000), misaligned or TCM-hole address is rejected at GO with CHnERR.
    field {
        sw = rw; hw = r;
        reset = 32'h0;
        vesta_access = "rw";
        desc = "Destination byte address (word-aligned).";
    } DMAC0DST[31:0];
};

reg DMAxC0LEN_t {
    regwidth = 32;
    desc = "Channel 0 transfer length in WORDS. Decrements as the engine runs (a read returns the current remaining count, so pointers/LEN show where an aborted transfer stopped, D15); reads 0 before the first GO. LEN=0 at GO is a programming error (CHnERR, no transfer issued, D13).";
    // Full 32-bit store; the READ returns len_work, the WORKING remaining count, not the programmed seed (0 until the first GO).
    field {
        sw = rw; hw = rw;
        reset = 32'h0;
        vesta_access = "rw";
        desc = "Remaining transfer length in words.";
    } DMAC0LEN[31:0];
};

reg DMAxC0CFG_t {
    regwidth = 32;
    desc = "Channel 0 configuration: source/dest auto-increment (SINC/DINC, +4 per word when set, else a fixed peripheral data register), trigger source (TRIG), channel priority class (PRIO) and CRC ride-along enable (CRCEN). Program before GO.";
    field {
        sw = rw; hw = r;
        reset = 1'h0;
        vesta_access = "rw";
        encode = dmaxc0cfg_dmac0crcen_e;
        desc = "CRC ride-along enable. When set, each transferred word is folded (bytes low-to-high) into the shared DMA0CRC accumulator (CRC16-CDMA2000, D14). Use one CRCEN channel per measurement session (a single shared accumulator).";
    } DMAC0CRCEN[7:7];
    field {
        sw = rw; hw = r;
        reset = 1'h0;
        vesta_access = "rw";
        encode = dmaxc0cfg_dmac0prio_e;
        desc = "Priority class. Among serviceable channels the high class (1) is picked before the low class (0); within a class a round-robin pointer prevents starvation (D7). A continuously-serviceable PRIO=1 channel can hold off PRIO=0 channels (standard DMA priority semantic).";
    } DMAC0PRIO[6:6];
    field {
        sw = rw; hw = r;
        reset = 4'h0;
        vesta_access = "rw";
        encode = dmaxc0cfg_dmac0trig_e;
        desc = "Trigger source (D9/D10/A8). 0 = software / mem-to-mem (continuously serviceable); 1 = UART0 RC (one word per received byte, read-to-clear); 2 = QSPI0 RX-full (one word per event + an extra W1C ack txn); 3 = NFC0 payload-ready (a frame event launches the full LEN-word burst + one ack); 4-15 reserved. Pacing requires the source peripheral's own receive interrupt-enable bit set (A8).";
    } DMAC0TRIG[5:2];
    field {
        sw = rw; hw = r;
        reset = 1'h0;
        vesta_access = "rw";
        encode = dmaxc0cfg_dmac0dinc_e;
        desc = "Destination auto-increment. 1 = dst += 4 per word; 0 = dst held (peripheral fill register, D11).";
    } DMAC0DINC[1:1];
    field {
        sw = rw; hw = r;
        reset = 1'h0;
        vesta_access = "rw";
        encode = dmaxc0cfg_dmac0sinc_e;
        desc = "Source auto-increment. 1 = src += 4 per word (block copy); 0 = src held (peripheral data register, the paced-drain case, D11).";
    } DMAC0SINC[0:0];
};

reg DMAxC1SRC_t {
    regwidth = 32;
    desc = "Channel 1 source byte address in the 0x0-0x1FFFF shared window (word-aligned: bits[1:0] must be 0; bits[31:17] must be 0). The full written 32-bit value reads back; the engine presents byte_ptr(16:2) as the 15-bit arbiter word address. A misaligned, out-of-window (>= 0x20000), or TCM-hole (0x8000-0xBFFF) SRC is rejected at GO with CHnERR (D13/A18).";
    // Full 32-bit store and readback; bits 31:17 are writable scratch. An out-of-window (>= 0x20000), misaligned or TCM-hole address is rejected at GO with CHnERR.
    field {
        sw = rw; hw = r;
        reset = 32'h0;
        vesta_access = "rw";
        desc = "Source byte address (word-aligned).";
    } DMAC1SRC[31:0];
};

reg DMAxC1DST_t {
    regwidth = 32;
    desc = "Channel 1 destination byte address (same word-aligned / in-window / TCM-hole rules as C1SRC, D13/A18).";
    // Full 32-bit store and readback; bits 31:17 are writable scratch. An out-of-window (>= 0x20000), misaligned or TCM-hole address is rejected at GO with CHnERR.
    field {
        sw = rw; hw = r;
        reset = 32'h0;
        vesta_access = "rw";
        desc = "Destination byte address (word-aligned).";
    } DMAC1DST[31:0];
};

reg DMAxC1LEN_t {
    regwidth = 32;
    desc = "Channel 1 transfer length in WORDS. Decrements as the engine runs (a read returns the current remaining count, so pointers/LEN show where an aborted transfer stopped, D15); reads 0 before the first GO. LEN=0 at GO is a programming error (CHnERR, no transfer issued, D13).";
    // Full 32-bit store; the READ returns len_work, the WORKING remaining count, not the programmed seed (0 until the first GO).
    field {
        sw = rw; hw = rw;
        reset = 32'h0;
        vesta_access = "rw";
        desc = "Remaining transfer length in words.";
    } DMAC1LEN[31:0];
};

reg DMAxC1CFG_t {
    regwidth = 32;
    desc = "Channel 1 configuration: source/dest auto-increment (SINC/DINC, +4 per word when set, else a fixed peripheral data register), trigger source (TRIG), channel priority class (PRIO) and CRC ride-along enable (CRCEN). Program before GO.";
    field {
        sw = rw; hw = r;
        reset = 1'h0;
        vesta_access = "rw";
        encode = dmaxc1cfg_dmac1crcen_e;
        desc = "CRC ride-along enable. When set, each transferred word is folded (bytes low-to-high) into the shared DMA0CRC accumulator (CRC16-CDMA2000, D14). Use one CRCEN channel per measurement session (a single shared accumulator).";
    } DMAC1CRCEN[7:7];
    field {
        sw = rw; hw = r;
        reset = 1'h0;
        vesta_access = "rw";
        encode = dmaxc1cfg_dmac1prio_e;
        desc = "Priority class. Among serviceable channels the high class (1) is picked before the low class (0); within a class a round-robin pointer prevents starvation (D7). A continuously-serviceable PRIO=1 channel can hold off PRIO=0 channels (standard DMA priority semantic).";
    } DMAC1PRIO[6:6];
    field {
        sw = rw; hw = r;
        reset = 4'h0;
        vesta_access = "rw";
        encode = dmaxc1cfg_dmac1trig_e;
        desc = "Trigger source (D9/D10/A8). 0 = software / mem-to-mem (continuously serviceable); 1 = UART0 RC (one word per received byte, read-to-clear); 2 = QSPI0 RX-full (one word per event + an extra W1C ack txn); 3 = NFC0 payload-ready (a frame event launches the full LEN-word burst + one ack); 4-15 reserved. Pacing requires the source peripheral's own receive interrupt-enable bit set (A8).";
    } DMAC1TRIG[5:2];
    field {
        sw = rw; hw = r;
        reset = 1'h0;
        vesta_access = "rw";
        encode = dmaxc1cfg_dmac1dinc_e;
        desc = "Destination auto-increment. 1 = dst += 4 per word; 0 = dst held (peripheral fill register, D11).";
    } DMAC1DINC[1:1];
    field {
        sw = rw; hw = r;
        reset = 1'h0;
        vesta_access = "rw";
        encode = dmaxc1cfg_dmac1sinc_e;
        desc = "Source auto-increment. 1 = src += 4 per word (block copy); 0 = src held (peripheral data register, the paced-drain case, D11).";
    } DMAC1SINC[0:0];
};

reg DMAxC2SRC_t {
    regwidth = 32;
    desc = "Channel 2 source byte address in the 0x0-0x1FFFF shared window (word-aligned: bits[1:0] must be 0; bits[31:17] must be 0). The full written 32-bit value reads back; the engine presents byte_ptr(16:2) as the 15-bit arbiter word address. A misaligned, out-of-window (>= 0x20000), or TCM-hole (0x8000-0xBFFF) SRC is rejected at GO with CHnERR (D13/A18). (reads 0 / ignores writes when the build has NCH=2)";
    // Full 32-bit store and readback; bits 31:17 are writable scratch. An out-of-window (>= 0x20000), misaligned or TCM-hole address is rejected at GO with CHnERR.
    field {
        sw = rw; hw = r;
        reset = 32'h0;
        vesta_access = "rw";
        desc = "Source byte address (word-aligned).";
    } DMAC2SRC[31:0];
};

reg DMAxC2DST_t {
    regwidth = 32;
    desc = "Channel 2 destination byte address (same word-aligned / in-window / TCM-hole rules as C2SRC, D13/A18). (reads 0 / ignores writes when the build has NCH=2)";
    // Full 32-bit store and readback; bits 31:17 are writable scratch. An out-of-window (>= 0x20000), misaligned or TCM-hole address is rejected at GO with CHnERR.
    field {
        sw = rw; hw = r;
        reset = 32'h0;
        vesta_access = "rw";
        desc = "Destination byte address (word-aligned).";
    } DMAC2DST[31:0];
};

reg DMAxC2LEN_t {
    regwidth = 32;
    desc = "Channel 2 transfer length in WORDS. Decrements as the engine runs (a read returns the current remaining count, so pointers/LEN show where an aborted transfer stopped, D15); reads 0 before the first GO. LEN=0 at GO is a programming error (CHnERR, no transfer issued, D13). (reads 0 / ignores writes when the build has NCH=2)";
    // Full 32-bit store; the READ returns len_work, the WORKING remaining count, not the programmed seed (0 until the first GO).
    field {
        sw = rw; hw = rw;
        reset = 32'h0;
        vesta_access = "rw";
        desc = "Remaining transfer length in words.";
    } DMAC2LEN[31:0];
};

reg DMAxC2CFG_t {
    regwidth = 32;
    desc = "Channel 2 configuration: source/dest auto-increment (SINC/DINC, +4 per word when set, else a fixed peripheral data register), trigger source (TRIG), channel priority class (PRIO) and CRC ride-along enable (CRCEN). Program before GO. (reads 0 / ignores writes when the build has NCH=2)";
    field {
        sw = rw; hw = r;
        reset = 1'h0;
        vesta_access = "rw";
        encode = dmaxc2cfg_dmac2crcen_e;
        desc = "CRC ride-along enable. When set, each transferred word is folded (bytes low-to-high) into the shared DMA0CRC accumulator (CRC16-CDMA2000, D14). Use one CRCEN channel per measurement session (a single shared accumulator).";
    } DMAC2CRCEN[7:7];
    field {
        sw = rw; hw = r;
        reset = 1'h0;
        vesta_access = "rw";
        encode = dmaxc2cfg_dmac2prio_e;
        desc = "Priority class. Among serviceable channels the high class (1) is picked before the low class (0); within a class a round-robin pointer prevents starvation (D7). A continuously-serviceable PRIO=1 channel can hold off PRIO=0 channels (standard DMA priority semantic).";
    } DMAC2PRIO[6:6];
    field {
        sw = rw; hw = r;
        reset = 4'h0;
        vesta_access = "rw";
        encode = dmaxc2cfg_dmac2trig_e;
        desc = "Trigger source (D9/D10/A8). 0 = software / mem-to-mem (continuously serviceable); 1 = UART0 RC (one word per received byte, read-to-clear); 2 = QSPI0 RX-full (one word per event + an extra W1C ack txn); 3 = NFC0 payload-ready (a frame event launches the full LEN-word burst + one ack); 4-15 reserved. Pacing requires the source peripheral's own receive interrupt-enable bit set (A8).";
    } DMAC2TRIG[5:2];
    field {
        sw = rw; hw = r;
        reset = 1'h0;
        vesta_access = "rw";
        encode = dmaxc2cfg_dmac2dinc_e;
        desc = "Destination auto-increment. 1 = dst += 4 per word; 0 = dst held (peripheral fill register, D11).";
    } DMAC2DINC[1:1];
    field {
        sw = rw; hw = r;
        reset = 1'h0;
        vesta_access = "rw";
        encode = dmaxc2cfg_dmac2sinc_e;
        desc = "Source auto-increment. 1 = src += 4 per word (block copy); 0 = src held (peripheral data register, the paced-drain case, D11).";
    } DMAC2SINC[0:0];
};

reg DMAxC3SRC_t {
    regwidth = 32;
    desc = "Channel 3 source byte address in the 0x0-0x1FFFF shared window (word-aligned: bits[1:0] must be 0; bits[31:17] must be 0). The full written 32-bit value reads back; the engine presents byte_ptr(16:2) as the 15-bit arbiter word address. A misaligned, out-of-window (>= 0x20000), or TCM-hole (0x8000-0xBFFF) SRC is rejected at GO with CHnERR (D13/A18). (reads 0 / ignores writes when the build has NCH=2)";
    // Full 32-bit store and readback; bits 31:17 are writable scratch. An out-of-window (>= 0x20000), misaligned or TCM-hole address is rejected at GO with CHnERR.
    field {
        sw = rw; hw = r;
        reset = 32'h0;
        vesta_access = "rw";
        desc = "Source byte address (word-aligned).";
    } DMAC3SRC[31:0];
};

reg DMAxC3DST_t {
    regwidth = 32;
    desc = "Channel 3 destination byte address (same word-aligned / in-window / TCM-hole rules as C3SRC, D13/A18). (reads 0 / ignores writes when the build has NCH=2)";
    // Full 32-bit store and readback; bits 31:17 are writable scratch. An out-of-window (>= 0x20000), misaligned or TCM-hole address is rejected at GO with CHnERR.
    field {
        sw = rw; hw = r;
        reset = 32'h0;
        vesta_access = "rw";
        desc = "Destination byte address (word-aligned).";
    } DMAC3DST[31:0];
};

reg DMAxC3LEN_t {
    regwidth = 32;
    desc = "Channel 3 transfer length in WORDS. Decrements as the engine runs (a read returns the current remaining count, so pointers/LEN show where an aborted transfer stopped, D15); reads 0 before the first GO. LEN=0 at GO is a programming error (CHnERR, no transfer issued, D13). (reads 0 / ignores writes when the build has NCH=2)";
    // Full 32-bit store; the READ returns len_work, the WORKING remaining count, not the programmed seed (0 until the first GO).
    field {
        sw = rw; hw = rw;
        reset = 32'h0;
        vesta_access = "rw";
        desc = "Remaining transfer length in words.";
    } DMAC3LEN[31:0];
};

reg DMAxC3CFG_t {
    regwidth = 32;
    desc = "Channel 3 configuration: source/dest auto-increment (SINC/DINC, +4 per word when set, else a fixed peripheral data register), trigger source (TRIG), channel priority class (PRIO) and CRC ride-along enable (CRCEN). Program before GO. (reads 0 / ignores writes when the build has NCH=2)";
    field {
        sw = rw; hw = r;
        reset = 1'h0;
        vesta_access = "rw";
        encode = dmaxc3cfg_dmac3crcen_e;
        desc = "CRC ride-along enable. When set, each transferred word is folded (bytes low-to-high) into the shared DMA0CRC accumulator (CRC16-CDMA2000, D14). Use one CRCEN channel per measurement session (a single shared accumulator).";
    } DMAC3CRCEN[7:7];
    field {
        sw = rw; hw = r;
        reset = 1'h0;
        vesta_access = "rw";
        encode = dmaxc3cfg_dmac3prio_e;
        desc = "Priority class. Among serviceable channels the high class (1) is picked before the low class (0); within a class a round-robin pointer prevents starvation (D7). A continuously-serviceable PRIO=1 channel can hold off PRIO=0 channels (standard DMA priority semantic).";
    } DMAC3PRIO[6:6];
    field {
        sw = rw; hw = r;
        reset = 4'h0;
        vesta_access = "rw";
        encode = dmaxc3cfg_dmac3trig_e;
        desc = "Trigger source (D9/D10/A8). 0 = software / mem-to-mem (continuously serviceable); 1 = UART0 RC (one word per received byte, read-to-clear); 2 = QSPI0 RX-full (one word per event + an extra W1C ack txn); 3 = NFC0 payload-ready (a frame event launches the full LEN-word burst + one ack); 4-15 reserved. Pacing requires the source peripheral's own receive interrupt-enable bit set (A8).";
    } DMAC3TRIG[5:2];
    field {
        sw = rw; hw = r;
        reset = 1'h0;
        vesta_access = "rw";
        encode = dmaxc3cfg_dmac3dinc_e;
        desc = "Destination auto-increment. 1 = dst += 4 per word; 0 = dst held (peripheral fill register, D11).";
    } DMAC3DINC[1:1];
    field {
        sw = rw; hw = r;
        reset = 1'h0;
        vesta_access = "rw";
        encode = dmaxc3cfg_dmac3sinc_e;
        desc = "Source auto-increment. 1 = src += 4 per word (block copy); 0 = src held (peripheral data register, the paced-drain case, D11).";
    } DMAC3SINC[0:0];
};

reg DMAxCRC_t {
    regwidth = 32;
    desc = "CRC16-CDMA2000 (poly 0xC857) accumulator / seed, resets to 0xFFFF. Firmware writes the 0xFFFF seed before GO (the SYSTEM0 seed-via-state convention, no auto-seed) and reads the result after DONE; the engine accumulates in the MCLK domain, feeding each CRCEN word's four bytes low-to-high. No input/output reflection, no final XOR (the work.CRC16 contract). Upper bits read 0.";
    // Resets to 0xFFFF. A write stages the seed and flips crc_wr_tgl; the clk-domain engine is the accumulator's only driver, so a read returns crc_acc, not the staged seed.
    field {
        sw = rw; hw = rw;
        reset = 16'hFFFF;
        vesta_access = "rw";
        desc = "CRC16-CDMA2000 accumulator/seed (reset 0xFFFF).";
    } DMACRC[15:0];
};

reg DMAxDESC_t {
    regwidth = 32;
    desc = "Reserved for a descriptor-chain head pointer (out of scope this single-shot phase). Reads 0, writes ignored -- provisioned so scatter-gather bolts on at this slot without a register-map break. Slots >= 20 also read 0.";
    field {
        sw = r;  hw = na;
        reset = 32'h0;
        desc = "Reserved.";
    } RESERVED[31:0];
};
addrmap dma {
    name = "DMAx";
    desc = "Configurable multi-channel single-shot DMA controller: it moves words source->dest over the shared arbiter as a stream of single-word transactions, either flat-out under software GO (memory-to-memory) or paced one word per peripheral data-ready event (UART0 RC / QSPI0 RX-full / NFC0 payload-ready), with optional per-channel source/dest auto-increment, a per-channel 2-level priority + word-granular";
    vesta_peripheral = "DMAx";
    vesta_word_base = 0;

    default regwidth = 32;

    DMAxCR_t    DMAxCR    @0x00;
    DMAxSR_t    DMAxSR    @0x04;
    DMAxC0SRC_t DMAxC0SRC @0x08;
    DMAxC0DST_t DMAxC0DST @0x0C;
    DMAxC0LEN_t DMAxC0LEN @0x10;
    DMAxC0CFG_t DMAxC0CFG @0x14;
    DMAxC1SRC_t DMAxC1SRC @0x18;
    DMAxC1DST_t DMAxC1DST @0x1C;
    DMAxC1LEN_t DMAxC1LEN @0x20;
    DMAxC1CFG_t DMAxC1CFG @0x24;
    DMAxC2SRC_t DMAxC2SRC @0x28;
    DMAxC2DST_t DMAxC2DST @0x2C;
    DMAxC2LEN_t DMAxC2LEN @0x30;
    DMAxC2CFG_t DMAxC2CFG @0x34;
    DMAxC3SRC_t DMAxC3SRC @0x38;
    DMAxC3DST_t DMAxC3DST @0x3C;
    DMAxC3LEN_t DMAxC3LEN @0x40;
    DMAxC3CFG_t DMAxC3CFG @0x44;
    DMAxCRC_t   DMAxCRC   @0x48;
    DMAxDESC_t  DMAxDESC  @0x4C;
};
