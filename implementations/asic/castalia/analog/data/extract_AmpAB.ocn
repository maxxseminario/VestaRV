;; generated by maestro2tex -- do not edit
procedure(mtxDump(fname wv)
  let((xs ys n p)
    p = outfile(fname "w")
    cond(
      (null(wv) fprintf(p "#nil\n"))
      (drIsWaveform(wv)
        xs = drGetWaveformXVec(wv)
        ys = drGetWaveformYVec(wv)
        n = drVectorLength(xs)
        for(i 0 n-1
          fprintf(p "%.10g %.10g\n" drGetElem(xs i) drGetElem(ys i)))
      )
      (t fprintf(p "#scalar %.10g\n" float(wv)))
    )
    close(p)
    t))

;; ---- corner 1 (tt) / test cab_cell_dc
when(isDir("/home/mseminario2/chips/castalia/ic/.simulation/castalia/tb_anatop_ctrl_amp_ab/maestro/results/maestro/Interactive.168/1/CellDriveTB/psf")
  openResults("/home/mseminario2/chips/castalia/ic/.simulation/castalia/tb_anatop_ctrl_amp_ab/maestro/results/maestro/Interactive.168/1/CellDriveTB/psf")
  when(member('dc results())
    selectResult('dc)
    mtxP = outfile("/home/mseminario2/vestarv/implementations/asic/castalia/analog/data/raw/cab_cell_dc__tt.meta" "w")
    fprintf(mtxP "sweep %%L\n" car(errset(sweepNames())))
    close(mtxP)
    errset(mtxDump("/home/mseminario2/vestarv/implementations/asic/castalia/analog/data/raw/cab_cell_dc__tt__ce_hi.csv" ymax(VS("/CE"))))
    errset(mtxDump("/home/mseminario2/vestarv/implementations/asic/castalia/analog/data/raw/cab_cell_dc__tt__ce_lo.csv" ymin(VS("/CE"))))
    errset(mtxDump("/home/mseminario2/vestarv/implementations/asic/castalia/analog/data/raw/cab_cell_dc__tt__ce_w.csv" VS("/CE")))
    errset(mtxDump("/home/mseminario2/vestarv/implementations/asic/castalia/analog/data/raw/cab_cell_dc__tt__i_sink_max.csv" abs(ymin(IS("/SRC_WE/PLUS")))))
    errset(mtxDump("/home/mseminario2/vestarv/implementations/asic/castalia/analog/data/raw/cab_cell_dc__tt__i_src_max.csv" ymax(IS("/SRC_WE/PLUS"))))
    errset(mtxDump("/home/mseminario2/vestarv/implementations/asic/castalia/analog/data/raw/cab_cell_dc__tt__re_err_0.csv" value((VS("/RE") - xval(VS("/RE"))) VAR("V_CM"))))
    errset(mtxDump("/home/mseminario2/vestarv/implementations/asic/castalia/analog/data/raw/cab_cell_dc__tt__re_err_max.csv" ymax(abs(clip((VS("/RE") - xval(VS("/RE"))) VAR("vref_lo") VAR("vref_hi"))))))
    errset(mtxDump("/home/mseminario2/vestarv/implementations/asic/castalia/analog/data/raw/cab_cell_dc__tt__re_err_slope.csv" ymax(abs(deriv(clip((VS("/RE") - xval(VS("/RE"))) VAR("vref_lo") VAR("vref_hi")))))))
    errset(mtxDump("/home/mseminario2/vestarv/implementations/asic/castalia/analog/data/raw/cab_cell_dc__tt__re_reg_n10.csv" (value((VS("/RE") - xval(VS("/RE"))) cross(IS("/SRC_WE/PLUS") -1e-05 1 "either")) - value((VS("/RE") - xval(VS("/RE"))) VAR("V_CM")))))
    errset(mtxDump("/home/mseminario2/vestarv/implementations/asic/castalia/analog/data/raw/cab_cell_dc__tt__re_reg_p10.csv" (value((VS("/RE") - xval(VS("/RE"))) cross(IS("/SRC_WE/PLUS") 1e-05 1 "either")) - value((VS("/RE") - xval(VS("/RE"))) VAR("V_CM")))))
  )
)

;; ---- corner 1 (tt) / test cab_cell_stb
when(isDir("/home/mseminario2/chips/castalia/ic/.simulation/castalia/tb_anatop_ctrl_amp_ab/maestro/results/maestro/Interactive.168/1/CellDriveTB/psf")
  openResults("/home/mseminario2/chips/castalia/ic/.simulation/castalia/tb_anatop_ctrl_amp_ab/maestro/results/maestro/Interactive.168/1/CellDriveTB/psf")
  when(member('stb results())
    selectResult('stb)
    mtxP = outfile("/home/mseminario2/vestarv/implementations/asic/castalia/analog/data/raw/cab_cell_stb__tt.meta" "w")
    fprintf(mtxP "sweep %%L\n" car(errset(sweepNames())))
    close(mtxP)
    errset(mtxDump("/home/mseminario2/vestarv/implementations/asic/castalia/analog/data/raw/cab_cell_stb__tt__cell_aol_db.csv" ymax(dB20(getData("loopGain" ?result "stb")))))
    errset(mtxDump("/home/mseminario2/vestarv/implementations/asic/castalia/analog/data/raw/cab_cell_stb__tt__cell_pm.csv" value(phase(getData("loopGain" ?result "stb")) cross(dB20(getData("loopGain" ?result "stb")) 0 1 "falling"))))
    errset(mtxDump("/home/mseminario2/vestarv/implementations/asic/castalia/analog/data/raw/cab_cell_stb__tt__cell_ugf.csv" cross(dB20(getData("loopGain" ?result "stb")) 0 1 "falling")))
  )
)

;; ---- corner 1 (tt) / test cab_drive_dc
when(isDir("/home/mseminario2/chips/castalia/ic/.simulation/castalia/tb_anatop_ctrl_amp_ab/maestro/results/maestro/Interactive.168/1/DriveTB/psf")
  openResults("/home/mseminario2/chips/castalia/ic/.simulation/castalia/tb_anatop_ctrl_amp_ab/maestro/results/maestro/Interactive.168/1/DriveTB/psf")
  when(member('dc results())
    selectResult('dc)
    mtxP = outfile("/home/mseminario2/vestarv/implementations/asic/castalia/analog/data/raw/cab_drive_dc__tt.meta" "w")
    fprintf(mtxP "sweep %%L\n" car(errset(sweepNames())))
    close(mtxP)
    errset(mtxDump("/home/mseminario2/vestarv/implementations/asic/castalia/analog/data/raw/cab_drive_dc__tt__Rout_cl.csv" abs(value(deriv(VS("/V_OutOL")) 0))))
    errset(mtxDump("/home/mseminario2/vestarv/implementations/asic/castalia/analog/data/raw/cab_drive_dc__tt__i_sink_50m.csv" cross(abs((VS("/V_OutOL") - VAR("V_CM"))) 0.05 1 "falling")))
    errset(mtxDump("/home/mseminario2/vestarv/implementations/asic/castalia/analog/data/raw/cab_drive_dc__tt__i_src_50m.csv" cross(abs((VS("/V_OutOL") - VAR("V_CM"))) 0.05 1 "rising")))
  )
)

;; ---- corner 1 (tt) / test cab_offset_dc
when(isDir("/home/mseminario2/chips/castalia/ic/.simulation/castalia/tb_anatop_ctrl_amp_ab/maestro/results/maestro/Interactive.168/1/OffsetCalTB/psf")
  openResults("/home/mseminario2/chips/castalia/ic/.simulation/castalia/tb_anatop_ctrl_amp_ab/maestro/results/maestro/Interactive.168/1/OffsetCalTB/psf")
  when(member('dc results())
    selectResult('dc)
    mtxP = outfile("/home/mseminario2/vestarv/implementations/asic/castalia/analog/data/raw/cab_offset_dc__tt.meta" "w")
    fprintf(mtxP "sweep %%L\n" car(errset(sweepNames())))
    close(mtxP)
    errset(mtxDump("/home/mseminario2/vestarv/implementations/asic/castalia/analog/data/raw/cab_offset_dc__tt__vos.csv" cross(VS("/V_OutOL") (VAR("VDD25") / 2) 1 "either" nil nil nil)))
  )
)

;; ---- corner 1 (tt) / test cab_ol_ac
when(isDir("/home/mseminario2/chips/castalia/ic/.simulation/castalia/tb_anatop_ctrl_amp_ab/maestro/results/maestro/Interactive.168/1/TypOpenLoopTB/psf")
  openResults("/home/mseminario2/chips/castalia/ic/.simulation/castalia/tb_anatop_ctrl_amp_ab/maestro/results/maestro/Interactive.168/1/TypOpenLoopTB/psf")
  when(member('ac results())
    selectResult('ac)
    mtxP = outfile("/home/mseminario2/vestarv/implementations/asic/castalia/analog/data/raw/cab_ol_ac__tt.meta" "w")
    fprintf(mtxP "sweep %%L\n" car(errset(sweepNames())))
    close(mtxP)
    errset(mtxDump("/home/mseminario2/vestarv/implementations/asic/castalia/analog/data/raw/cab_ol_ac__tt__ol_f3db.csv" bandwidth((VF("/V_OutOL") / (VF("/V_InP") - VF("/V_InM"))) 3 "low")))
    errset(mtxDump("/home/mseminario2/vestarv/implementations/asic/castalia/analog/data/raw/cab_ol_ac__tt__ol_fu.csv" unityGainFreq((VF("/V_OutOL") / (VF("/V_InP") - VF("/V_InM"))))))
    errset(mtxDump("/home/mseminario2/vestarv/implementations/asic/castalia/analog/data/raw/cab_ol_ac__tt__ol_gain_db.csv" dB20(ymax(mag((VF("/V_OutOL") / (VF("/V_InP") - VF("/V_InM"))))))))
    errset(mtxDump("/home/mseminario2/vestarv/implementations/asic/castalia/analog/data/raw/cab_ol_ac__tt__ol_pm.csv" phaseMargin((VF("/V_OutOL") / (VF("/V_InP") - VF("/V_InM"))))))
  )
)

;; ---- corner 1 (tt) / test cab_ol_dcop
when(isDir("/home/mseminario2/chips/castalia/ic/.simulation/castalia/tb_anatop_ctrl_amp_ab/maestro/results/maestro/Interactive.168/1/TypOpenLoopTB/psf")
  openResults("/home/mseminario2/chips/castalia/ic/.simulation/castalia/tb_anatop_ctrl_amp_ab/maestro/results/maestro/Interactive.168/1/TypOpenLoopTB/psf")
  when(member('dcOp results())
    selectResult('dcOp)
    mtxP = outfile("/home/mseminario2/vestarv/implementations/asic/castalia/analog/data/raw/cab_ol_dcop__tt.meta" "w")
    fprintf(mtxP "sweep %%L\n" car(errset(sweepNames())))
    close(mtxP)
    errset(mtxDump("/home/mseminario2/vestarv/implementations/asic/castalia/analog/data/raw/cab_ol_dcop__tt__ol_itot.csv" abs(IDC("/POWER/SRC_VDD25/PLUS"))))
    errset(mtxDump("/home/mseminario2/vestarv/implementations/asic/castalia/analog/data/raw/cab_ol_dcop__tt__ol_ptot.csv" (abs(IDC("/POWER/SRC_VDD25/PLUS")) * VAR("VDD25"))))
  )
)

;; ---- corner 1 (tt) / test cab_unity_stb
when(isDir("/home/mseminario2/chips/castalia/ic/.simulation/castalia/tb_anatop_ctrl_amp_ab/maestro/results/maestro/Interactive.168/1/UnityFeedbackTB/psf")
  openResults("/home/mseminario2/chips/castalia/ic/.simulation/castalia/tb_anatop_ctrl_amp_ab/maestro/results/maestro/Interactive.168/1/UnityFeedbackTB/psf")
  when(member('stb results())
    selectResult('stb)
    mtxP = outfile("/home/mseminario2/vestarv/implementations/asic/castalia/analog/data/raw/cab_unity_stb__tt.meta" "w")
    fprintf(mtxP "sweep %%L\n" car(errset(sweepNames())))
    close(mtxP)
    errset(mtxDump("/home/mseminario2/vestarv/implementations/asic/castalia/analog/data/raw/cab_unity_stb__tt__uf_aol_db.csv" ymax(dB20(getData("loopGain" ?result "stb")))))
    errset(mtxDump("/home/mseminario2/vestarv/implementations/asic/castalia/analog/data/raw/cab_unity_stb__tt__uf_gm.csv" (- value(dB20(getData("loopGain" ?result "stb")) cross(phase(getData("loopGain" ?result "stb")) 0 1 "falling")))))
    errset(mtxDump("/home/mseminario2/vestarv/implementations/asic/castalia/analog/data/raw/cab_unity_stb__tt__uf_pm.csv" value(phase(getData("loopGain" ?result "stb")) cross(dB20(getData("loopGain" ?result "stb")) 0 1 "falling"))))
    errset(mtxDump("/home/mseminario2/vestarv/implementations/asic/castalia/analog/data/raw/cab_unity_stb__tt__uf_ugf.csv" cross(dB20(getData("loopGain" ?result "stb")) 0 1 "falling")))
  )
)

;; ---- corner 2 (ff) / test cab_cell_dc
when(isDir("/home/mseminario2/chips/castalia/ic/.simulation/castalia/tb_anatop_ctrl_amp_ab/maestro/results/maestro/Interactive.168/2/CellDriveTB/psf")
  openResults("/home/mseminario2/chips/castalia/ic/.simulation/castalia/tb_anatop_ctrl_amp_ab/maestro/results/maestro/Interactive.168/2/CellDriveTB/psf")
  when(member('dc results())
    selectResult('dc)
    mtxP = outfile("/home/mseminario2/vestarv/implementations/asic/castalia/analog/data/raw/cab_cell_dc__ff.meta" "w")
    fprintf(mtxP "sweep %%L\n" car(errset(sweepNames())))
    close(mtxP)
    errset(mtxDump("/home/mseminario2/vestarv/implementations/asic/castalia/analog/data/raw/cab_cell_dc__ff__ce_hi.csv" ymax(VS("/CE"))))
    errset(mtxDump("/home/mseminario2/vestarv/implementations/asic/castalia/analog/data/raw/cab_cell_dc__ff__ce_lo.csv" ymin(VS("/CE"))))
    errset(mtxDump("/home/mseminario2/vestarv/implementations/asic/castalia/analog/data/raw/cab_cell_dc__ff__ce_w.csv" VS("/CE")))
    errset(mtxDump("/home/mseminario2/vestarv/implementations/asic/castalia/analog/data/raw/cab_cell_dc__ff__i_sink_max.csv" abs(ymin(IS("/SRC_WE/PLUS")))))
    errset(mtxDump("/home/mseminario2/vestarv/implementations/asic/castalia/analog/data/raw/cab_cell_dc__ff__i_src_max.csv" ymax(IS("/SRC_WE/PLUS"))))
    errset(mtxDump("/home/mseminario2/vestarv/implementations/asic/castalia/analog/data/raw/cab_cell_dc__ff__re_err_0.csv" value((VS("/RE") - xval(VS("/RE"))) VAR("V_CM"))))
    errset(mtxDump("/home/mseminario2/vestarv/implementations/asic/castalia/analog/data/raw/cab_cell_dc__ff__re_err_max.csv" ymax(abs(clip((VS("/RE") - xval(VS("/RE"))) VAR("vref_lo") VAR("vref_hi"))))))
    errset(mtxDump("/home/mseminario2/vestarv/implementations/asic/castalia/analog/data/raw/cab_cell_dc__ff__re_err_slope.csv" ymax(abs(deriv(clip((VS("/RE") - xval(VS("/RE"))) VAR("vref_lo") VAR("vref_hi")))))))
    errset(mtxDump("/home/mseminario2/vestarv/implementations/asic/castalia/analog/data/raw/cab_cell_dc__ff__re_reg_n10.csv" (value((VS("/RE") - xval(VS("/RE"))) cross(IS("/SRC_WE/PLUS") -1e-05 1 "either")) - value((VS("/RE") - xval(VS("/RE"))) VAR("V_CM")))))
    errset(mtxDump("/home/mseminario2/vestarv/implementations/asic/castalia/analog/data/raw/cab_cell_dc__ff__re_reg_p10.csv" (value((VS("/RE") - xval(VS("/RE"))) cross(IS("/SRC_WE/PLUS") 1e-05 1 "either")) - value((VS("/RE") - xval(VS("/RE"))) VAR("V_CM")))))
  )
)

;; ---- corner 2 (ff) / test cab_cell_stb
when(isDir("/home/mseminario2/chips/castalia/ic/.simulation/castalia/tb_anatop_ctrl_amp_ab/maestro/results/maestro/Interactive.168/2/CellDriveTB/psf")
  openResults("/home/mseminario2/chips/castalia/ic/.simulation/castalia/tb_anatop_ctrl_amp_ab/maestro/results/maestro/Interactive.168/2/CellDriveTB/psf")
  when(member('stb results())
    selectResult('stb)
    mtxP = outfile("/home/mseminario2/vestarv/implementations/asic/castalia/analog/data/raw/cab_cell_stb__ff.meta" "w")
    fprintf(mtxP "sweep %%L\n" car(errset(sweepNames())))
    close(mtxP)
    errset(mtxDump("/home/mseminario2/vestarv/implementations/asic/castalia/analog/data/raw/cab_cell_stb__ff__cell_aol_db.csv" ymax(dB20(getData("loopGain" ?result "stb")))))
    errset(mtxDump("/home/mseminario2/vestarv/implementations/asic/castalia/analog/data/raw/cab_cell_stb__ff__cell_pm.csv" value(phase(getData("loopGain" ?result "stb")) cross(dB20(getData("loopGain" ?result "stb")) 0 1 "falling"))))
    errset(mtxDump("/home/mseminario2/vestarv/implementations/asic/castalia/analog/data/raw/cab_cell_stb__ff__cell_ugf.csv" cross(dB20(getData("loopGain" ?result "stb")) 0 1 "falling")))
  )
)

;; ---- corner 2 (ff) / test cab_drive_dc
when(isDir("/home/mseminario2/chips/castalia/ic/.simulation/castalia/tb_anatop_ctrl_amp_ab/maestro/results/maestro/Interactive.168/2/DriveTB/psf")
  openResults("/home/mseminario2/chips/castalia/ic/.simulation/castalia/tb_anatop_ctrl_amp_ab/maestro/results/maestro/Interactive.168/2/DriveTB/psf")
  when(member('dc results())
    selectResult('dc)
    mtxP = outfile("/home/mseminario2/vestarv/implementations/asic/castalia/analog/data/raw/cab_drive_dc__ff.meta" "w")
    fprintf(mtxP "sweep %%L\n" car(errset(sweepNames())))
    close(mtxP)
    errset(mtxDump("/home/mseminario2/vestarv/implementations/asic/castalia/analog/data/raw/cab_drive_dc__ff__Rout_cl.csv" abs(value(deriv(VS("/V_OutOL")) 0))))
    errset(mtxDump("/home/mseminario2/vestarv/implementations/asic/castalia/analog/data/raw/cab_drive_dc__ff__i_sink_50m.csv" cross(abs((VS("/V_OutOL") - VAR("V_CM"))) 0.05 1 "falling")))
    errset(mtxDump("/home/mseminario2/vestarv/implementations/asic/castalia/analog/data/raw/cab_drive_dc__ff__i_src_50m.csv" cross(abs((VS("/V_OutOL") - VAR("V_CM"))) 0.05 1 "rising")))
  )
)

;; ---- corner 2 (ff) / test cab_offset_dc
when(isDir("/home/mseminario2/chips/castalia/ic/.simulation/castalia/tb_anatop_ctrl_amp_ab/maestro/results/maestro/Interactive.168/2/OffsetCalTB/psf")
  openResults("/home/mseminario2/chips/castalia/ic/.simulation/castalia/tb_anatop_ctrl_amp_ab/maestro/results/maestro/Interactive.168/2/OffsetCalTB/psf")
  when(member('dc results())
    selectResult('dc)
    mtxP = outfile("/home/mseminario2/vestarv/implementations/asic/castalia/analog/data/raw/cab_offset_dc__ff.meta" "w")
    fprintf(mtxP "sweep %%L\n" car(errset(sweepNames())))
    close(mtxP)
    errset(mtxDump("/home/mseminario2/vestarv/implementations/asic/castalia/analog/data/raw/cab_offset_dc__ff__vos.csv" cross(VS("/V_OutOL") (VAR("VDD25") / 2) 1 "either" nil nil nil)))
  )
)

;; ---- corner 2 (ff) / test cab_ol_ac
when(isDir("/home/mseminario2/chips/castalia/ic/.simulation/castalia/tb_anatop_ctrl_amp_ab/maestro/results/maestro/Interactive.168/2/TypOpenLoopTB/psf")
  openResults("/home/mseminario2/chips/castalia/ic/.simulation/castalia/tb_anatop_ctrl_amp_ab/maestro/results/maestro/Interactive.168/2/TypOpenLoopTB/psf")
  when(member('ac results())
    selectResult('ac)
    mtxP = outfile("/home/mseminario2/vestarv/implementations/asic/castalia/analog/data/raw/cab_ol_ac__ff.meta" "w")
    fprintf(mtxP "sweep %%L\n" car(errset(sweepNames())))
    close(mtxP)
    errset(mtxDump("/home/mseminario2/vestarv/implementations/asic/castalia/analog/data/raw/cab_ol_ac__ff__ol_f3db.csv" bandwidth((VF("/V_OutOL") / (VF("/V_InP") - VF("/V_InM"))) 3 "low")))
    errset(mtxDump("/home/mseminario2/vestarv/implementations/asic/castalia/analog/data/raw/cab_ol_ac__ff__ol_fu.csv" unityGainFreq((VF("/V_OutOL") / (VF("/V_InP") - VF("/V_InM"))))))
    errset(mtxDump("/home/mseminario2/vestarv/implementations/asic/castalia/analog/data/raw/cab_ol_ac__ff__ol_gain_db.csv" dB20(ymax(mag((VF("/V_OutOL") / (VF("/V_InP") - VF("/V_InM"))))))))
    errset(mtxDump("/home/mseminario2/vestarv/implementations/asic/castalia/analog/data/raw/cab_ol_ac__ff__ol_pm.csv" phaseMargin((VF("/V_OutOL") / (VF("/V_InP") - VF("/V_InM"))))))
  )
)

;; ---- corner 2 (ff) / test cab_ol_dcop
when(isDir("/home/mseminario2/chips/castalia/ic/.simulation/castalia/tb_anatop_ctrl_amp_ab/maestro/results/maestro/Interactive.168/2/TypOpenLoopTB/psf")
  openResults("/home/mseminario2/chips/castalia/ic/.simulation/castalia/tb_anatop_ctrl_amp_ab/maestro/results/maestro/Interactive.168/2/TypOpenLoopTB/psf")
  when(member('dcOp results())
    selectResult('dcOp)
    mtxP = outfile("/home/mseminario2/vestarv/implementations/asic/castalia/analog/data/raw/cab_ol_dcop__ff.meta" "w")
    fprintf(mtxP "sweep %%L\n" car(errset(sweepNames())))
    close(mtxP)
    errset(mtxDump("/home/mseminario2/vestarv/implementations/asic/castalia/analog/data/raw/cab_ol_dcop__ff__ol_itot.csv" abs(IDC("/POWER/SRC_VDD25/PLUS"))))
    errset(mtxDump("/home/mseminario2/vestarv/implementations/asic/castalia/analog/data/raw/cab_ol_dcop__ff__ol_ptot.csv" (abs(IDC("/POWER/SRC_VDD25/PLUS")) * VAR("VDD25"))))
  )
)

;; ---- corner 2 (ff) / test cab_unity_stb
when(isDir("/home/mseminario2/chips/castalia/ic/.simulation/castalia/tb_anatop_ctrl_amp_ab/maestro/results/maestro/Interactive.168/2/UnityFeedbackTB/psf")
  openResults("/home/mseminario2/chips/castalia/ic/.simulation/castalia/tb_anatop_ctrl_amp_ab/maestro/results/maestro/Interactive.168/2/UnityFeedbackTB/psf")
  when(member('stb results())
    selectResult('stb)
    mtxP = outfile("/home/mseminario2/vestarv/implementations/asic/castalia/analog/data/raw/cab_unity_stb__ff.meta" "w")
    fprintf(mtxP "sweep %%L\n" car(errset(sweepNames())))
    close(mtxP)
    errset(mtxDump("/home/mseminario2/vestarv/implementations/asic/castalia/analog/data/raw/cab_unity_stb__ff__uf_aol_db.csv" ymax(dB20(getData("loopGain" ?result "stb")))))
    errset(mtxDump("/home/mseminario2/vestarv/implementations/asic/castalia/analog/data/raw/cab_unity_stb__ff__uf_gm.csv" (- value(dB20(getData("loopGain" ?result "stb")) cross(phase(getData("loopGain" ?result "stb")) 0 1 "falling")))))
    errset(mtxDump("/home/mseminario2/vestarv/implementations/asic/castalia/analog/data/raw/cab_unity_stb__ff__uf_pm.csv" value(phase(getData("loopGain" ?result "stb")) cross(dB20(getData("loopGain" ?result "stb")) 0 1 "falling"))))
    errset(mtxDump("/home/mseminario2/vestarv/implementations/asic/castalia/analog/data/raw/cab_unity_stb__ff__uf_ugf.csv" cross(dB20(getData("loopGain" ?result "stb")) 0 1 "falling")))
  )
)

;; ---- corner 3 (fs) / test cab_cell_dc
when(isDir("/home/mseminario2/chips/castalia/ic/.simulation/castalia/tb_anatop_ctrl_amp_ab/maestro/results/maestro/Interactive.168/3/CellDriveTB/psf")
  openResults("/home/mseminario2/chips/castalia/ic/.simulation/castalia/tb_anatop_ctrl_amp_ab/maestro/results/maestro/Interactive.168/3/CellDriveTB/psf")
  when(member('dc results())
    selectResult('dc)
    mtxP = outfile("/home/mseminario2/vestarv/implementations/asic/castalia/analog/data/raw/cab_cell_dc__fs.meta" "w")
    fprintf(mtxP "sweep %%L\n" car(errset(sweepNames())))
    close(mtxP)
    errset(mtxDump("/home/mseminario2/vestarv/implementations/asic/castalia/analog/data/raw/cab_cell_dc__fs__ce_hi.csv" ymax(VS("/CE"))))
    errset(mtxDump("/home/mseminario2/vestarv/implementations/asic/castalia/analog/data/raw/cab_cell_dc__fs__ce_lo.csv" ymin(VS("/CE"))))
    errset(mtxDump("/home/mseminario2/vestarv/implementations/asic/castalia/analog/data/raw/cab_cell_dc__fs__ce_w.csv" VS("/CE")))
    errset(mtxDump("/home/mseminario2/vestarv/implementations/asic/castalia/analog/data/raw/cab_cell_dc__fs__i_sink_max.csv" abs(ymin(IS("/SRC_WE/PLUS")))))
    errset(mtxDump("/home/mseminario2/vestarv/implementations/asic/castalia/analog/data/raw/cab_cell_dc__fs__i_src_max.csv" ymax(IS("/SRC_WE/PLUS"))))
    errset(mtxDump("/home/mseminario2/vestarv/implementations/asic/castalia/analog/data/raw/cab_cell_dc__fs__re_err_0.csv" value((VS("/RE") - xval(VS("/RE"))) VAR("V_CM"))))
    errset(mtxDump("/home/mseminario2/vestarv/implementations/asic/castalia/analog/data/raw/cab_cell_dc__fs__re_err_max.csv" ymax(abs(clip((VS("/RE") - xval(VS("/RE"))) VAR("vref_lo") VAR("vref_hi"))))))
    errset(mtxDump("/home/mseminario2/vestarv/implementations/asic/castalia/analog/data/raw/cab_cell_dc__fs__re_err_slope.csv" ymax(abs(deriv(clip((VS("/RE") - xval(VS("/RE"))) VAR("vref_lo") VAR("vref_hi")))))))
    errset(mtxDump("/home/mseminario2/vestarv/implementations/asic/castalia/analog/data/raw/cab_cell_dc__fs__re_reg_n10.csv" (value((VS("/RE") - xval(VS("/RE"))) cross(IS("/SRC_WE/PLUS") -1e-05 1 "either")) - value((VS("/RE") - xval(VS("/RE"))) VAR("V_CM")))))
    errset(mtxDump("/home/mseminario2/vestarv/implementations/asic/castalia/analog/data/raw/cab_cell_dc__fs__re_reg_p10.csv" (value((VS("/RE") - xval(VS("/RE"))) cross(IS("/SRC_WE/PLUS") 1e-05 1 "either")) - value((VS("/RE") - xval(VS("/RE"))) VAR("V_CM")))))
  )
)

;; ---- corner 3 (fs) / test cab_cell_stb
when(isDir("/home/mseminario2/chips/castalia/ic/.simulation/castalia/tb_anatop_ctrl_amp_ab/maestro/results/maestro/Interactive.168/3/CellDriveTB/psf")
  openResults("/home/mseminario2/chips/castalia/ic/.simulation/castalia/tb_anatop_ctrl_amp_ab/maestro/results/maestro/Interactive.168/3/CellDriveTB/psf")
  when(member('stb results())
    selectResult('stb)
    mtxP = outfile("/home/mseminario2/vestarv/implementations/asic/castalia/analog/data/raw/cab_cell_stb__fs.meta" "w")
    fprintf(mtxP "sweep %%L\n" car(errset(sweepNames())))
    close(mtxP)
    errset(mtxDump("/home/mseminario2/vestarv/implementations/asic/castalia/analog/data/raw/cab_cell_stb__fs__cell_aol_db.csv" ymax(dB20(getData("loopGain" ?result "stb")))))
    errset(mtxDump("/home/mseminario2/vestarv/implementations/asic/castalia/analog/data/raw/cab_cell_stb__fs__cell_pm.csv" value(phase(getData("loopGain" ?result "stb")) cross(dB20(getData("loopGain" ?result "stb")) 0 1 "falling"))))
    errset(mtxDump("/home/mseminario2/vestarv/implementations/asic/castalia/analog/data/raw/cab_cell_stb__fs__cell_ugf.csv" cross(dB20(getData("loopGain" ?result "stb")) 0 1 "falling")))
  )
)

;; ---- corner 3 (fs) / test cab_drive_dc
when(isDir("/home/mseminario2/chips/castalia/ic/.simulation/castalia/tb_anatop_ctrl_amp_ab/maestro/results/maestro/Interactive.168/3/DriveTB/psf")
  openResults("/home/mseminario2/chips/castalia/ic/.simulation/castalia/tb_anatop_ctrl_amp_ab/maestro/results/maestro/Interactive.168/3/DriveTB/psf")
  when(member('dc results())
    selectResult('dc)
    mtxP = outfile("/home/mseminario2/vestarv/implementations/asic/castalia/analog/data/raw/cab_drive_dc__fs.meta" "w")
    fprintf(mtxP "sweep %%L\n" car(errset(sweepNames())))
    close(mtxP)
    errset(mtxDump("/home/mseminario2/vestarv/implementations/asic/castalia/analog/data/raw/cab_drive_dc__fs__Rout_cl.csv" abs(value(deriv(VS("/V_OutOL")) 0))))
    errset(mtxDump("/home/mseminario2/vestarv/implementations/asic/castalia/analog/data/raw/cab_drive_dc__fs__i_sink_50m.csv" cross(abs((VS("/V_OutOL") - VAR("V_CM"))) 0.05 1 "falling")))
    errset(mtxDump("/home/mseminario2/vestarv/implementations/asic/castalia/analog/data/raw/cab_drive_dc__fs__i_src_50m.csv" cross(abs((VS("/V_OutOL") - VAR("V_CM"))) 0.05 1 "rising")))
  )
)

;; ---- corner 3 (fs) / test cab_offset_dc
when(isDir("/home/mseminario2/chips/castalia/ic/.simulation/castalia/tb_anatop_ctrl_amp_ab/maestro/results/maestro/Interactive.168/3/OffsetCalTB/psf")
  openResults("/home/mseminario2/chips/castalia/ic/.simulation/castalia/tb_anatop_ctrl_amp_ab/maestro/results/maestro/Interactive.168/3/OffsetCalTB/psf")
  when(member('dc results())
    selectResult('dc)
    mtxP = outfile("/home/mseminario2/vestarv/implementations/asic/castalia/analog/data/raw/cab_offset_dc__fs.meta" "w")
    fprintf(mtxP "sweep %%L\n" car(errset(sweepNames())))
    close(mtxP)
    errset(mtxDump("/home/mseminario2/vestarv/implementations/asic/castalia/analog/data/raw/cab_offset_dc__fs__vos.csv" cross(VS("/V_OutOL") (VAR("VDD25") / 2) 1 "either" nil nil nil)))
  )
)

;; ---- corner 3 (fs) / test cab_ol_ac
when(isDir("/home/mseminario2/chips/castalia/ic/.simulation/castalia/tb_anatop_ctrl_amp_ab/maestro/results/maestro/Interactive.168/3/TypOpenLoopTB/psf")
  openResults("/home/mseminario2/chips/castalia/ic/.simulation/castalia/tb_anatop_ctrl_amp_ab/maestro/results/maestro/Interactive.168/3/TypOpenLoopTB/psf")
  when(member('ac results())
    selectResult('ac)
    mtxP = outfile("/home/mseminario2/vestarv/implementations/asic/castalia/analog/data/raw/cab_ol_ac__fs.meta" "w")
    fprintf(mtxP "sweep %%L\n" car(errset(sweepNames())))
    close(mtxP)
    errset(mtxDump("/home/mseminario2/vestarv/implementations/asic/castalia/analog/data/raw/cab_ol_ac__fs__ol_f3db.csv" bandwidth((VF("/V_OutOL") / (VF("/V_InP") - VF("/V_InM"))) 3 "low")))
    errset(mtxDump("/home/mseminario2/vestarv/implementations/asic/castalia/analog/data/raw/cab_ol_ac__fs__ol_fu.csv" unityGainFreq((VF("/V_OutOL") / (VF("/V_InP") - VF("/V_InM"))))))
    errset(mtxDump("/home/mseminario2/vestarv/implementations/asic/castalia/analog/data/raw/cab_ol_ac__fs__ol_gain_db.csv" dB20(ymax(mag((VF("/V_OutOL") / (VF("/V_InP") - VF("/V_InM"))))))))
    errset(mtxDump("/home/mseminario2/vestarv/implementations/asic/castalia/analog/data/raw/cab_ol_ac__fs__ol_pm.csv" phaseMargin((VF("/V_OutOL") / (VF("/V_InP") - VF("/V_InM"))))))
  )
)

;; ---- corner 3 (fs) / test cab_ol_dcop
when(isDir("/home/mseminario2/chips/castalia/ic/.simulation/castalia/tb_anatop_ctrl_amp_ab/maestro/results/maestro/Interactive.168/3/TypOpenLoopTB/psf")
  openResults("/home/mseminario2/chips/castalia/ic/.simulation/castalia/tb_anatop_ctrl_amp_ab/maestro/results/maestro/Interactive.168/3/TypOpenLoopTB/psf")
  when(member('dcOp results())
    selectResult('dcOp)
    mtxP = outfile("/home/mseminario2/vestarv/implementations/asic/castalia/analog/data/raw/cab_ol_dcop__fs.meta" "w")
    fprintf(mtxP "sweep %%L\n" car(errset(sweepNames())))
    close(mtxP)
    errset(mtxDump("/home/mseminario2/vestarv/implementations/asic/castalia/analog/data/raw/cab_ol_dcop__fs__ol_itot.csv" abs(IDC("/POWER/SRC_VDD25/PLUS"))))
    errset(mtxDump("/home/mseminario2/vestarv/implementations/asic/castalia/analog/data/raw/cab_ol_dcop__fs__ol_ptot.csv" (abs(IDC("/POWER/SRC_VDD25/PLUS")) * VAR("VDD25"))))
  )
)

;; ---- corner 3 (fs) / test cab_unity_stb
when(isDir("/home/mseminario2/chips/castalia/ic/.simulation/castalia/tb_anatop_ctrl_amp_ab/maestro/results/maestro/Interactive.168/3/UnityFeedbackTB/psf")
  openResults("/home/mseminario2/chips/castalia/ic/.simulation/castalia/tb_anatop_ctrl_amp_ab/maestro/results/maestro/Interactive.168/3/UnityFeedbackTB/psf")
  when(member('stb results())
    selectResult('stb)
    mtxP = outfile("/home/mseminario2/vestarv/implementations/asic/castalia/analog/data/raw/cab_unity_stb__fs.meta" "w")
    fprintf(mtxP "sweep %%L\n" car(errset(sweepNames())))
    close(mtxP)
    errset(mtxDump("/home/mseminario2/vestarv/implementations/asic/castalia/analog/data/raw/cab_unity_stb__fs__uf_aol_db.csv" ymax(dB20(getData("loopGain" ?result "stb")))))
    errset(mtxDump("/home/mseminario2/vestarv/implementations/asic/castalia/analog/data/raw/cab_unity_stb__fs__uf_gm.csv" (- value(dB20(getData("loopGain" ?result "stb")) cross(phase(getData("loopGain" ?result "stb")) 0 1 "falling")))))
    errset(mtxDump("/home/mseminario2/vestarv/implementations/asic/castalia/analog/data/raw/cab_unity_stb__fs__uf_pm.csv" value(phase(getData("loopGain" ?result "stb")) cross(dB20(getData("loopGain" ?result "stb")) 0 1 "falling"))))
    errset(mtxDump("/home/mseminario2/vestarv/implementations/asic/castalia/analog/data/raw/cab_unity_stb__fs__uf_ugf.csv" cross(dB20(getData("loopGain" ?result "stb")) 0 1 "falling")))
  )
)

;; ---- corner 4 (sf) / test cab_cell_dc
when(isDir("/home/mseminario2/chips/castalia/ic/.simulation/castalia/tb_anatop_ctrl_amp_ab/maestro/results/maestro/Interactive.168/4/CellDriveTB/psf")
  openResults("/home/mseminario2/chips/castalia/ic/.simulation/castalia/tb_anatop_ctrl_amp_ab/maestro/results/maestro/Interactive.168/4/CellDriveTB/psf")
  when(member('dc results())
    selectResult('dc)
    mtxP = outfile("/home/mseminario2/vestarv/implementations/asic/castalia/analog/data/raw/cab_cell_dc__sf.meta" "w")
    fprintf(mtxP "sweep %%L\n" car(errset(sweepNames())))
    close(mtxP)
    errset(mtxDump("/home/mseminario2/vestarv/implementations/asic/castalia/analog/data/raw/cab_cell_dc__sf__ce_hi.csv" ymax(VS("/CE"))))
    errset(mtxDump("/home/mseminario2/vestarv/implementations/asic/castalia/analog/data/raw/cab_cell_dc__sf__ce_lo.csv" ymin(VS("/CE"))))
    errset(mtxDump("/home/mseminario2/vestarv/implementations/asic/castalia/analog/data/raw/cab_cell_dc__sf__ce_w.csv" VS("/CE")))
    errset(mtxDump("/home/mseminario2/vestarv/implementations/asic/castalia/analog/data/raw/cab_cell_dc__sf__i_sink_max.csv" abs(ymin(IS("/SRC_WE/PLUS")))))
    errset(mtxDump("/home/mseminario2/vestarv/implementations/asic/castalia/analog/data/raw/cab_cell_dc__sf__i_src_max.csv" ymax(IS("/SRC_WE/PLUS"))))
    errset(mtxDump("/home/mseminario2/vestarv/implementations/asic/castalia/analog/data/raw/cab_cell_dc__sf__re_err_0.csv" value((VS("/RE") - xval(VS("/RE"))) VAR("V_CM"))))
    errset(mtxDump("/home/mseminario2/vestarv/implementations/asic/castalia/analog/data/raw/cab_cell_dc__sf__re_err_max.csv" ymax(abs(clip((VS("/RE") - xval(VS("/RE"))) VAR("vref_lo") VAR("vref_hi"))))))
    errset(mtxDump("/home/mseminario2/vestarv/implementations/asic/castalia/analog/data/raw/cab_cell_dc__sf__re_err_slope.csv" ymax(abs(deriv(clip((VS("/RE") - xval(VS("/RE"))) VAR("vref_lo") VAR("vref_hi")))))))
    errset(mtxDump("/home/mseminario2/vestarv/implementations/asic/castalia/analog/data/raw/cab_cell_dc__sf__re_reg_n10.csv" (value((VS("/RE") - xval(VS("/RE"))) cross(IS("/SRC_WE/PLUS") -1e-05 1 "either")) - value((VS("/RE") - xval(VS("/RE"))) VAR("V_CM")))))
    errset(mtxDump("/home/mseminario2/vestarv/implementations/asic/castalia/analog/data/raw/cab_cell_dc__sf__re_reg_p10.csv" (value((VS("/RE") - xval(VS("/RE"))) cross(IS("/SRC_WE/PLUS") 1e-05 1 "either")) - value((VS("/RE") - xval(VS("/RE"))) VAR("V_CM")))))
  )
)

;; ---- corner 4 (sf) / test cab_cell_stb
when(isDir("/home/mseminario2/chips/castalia/ic/.simulation/castalia/tb_anatop_ctrl_amp_ab/maestro/results/maestro/Interactive.168/4/CellDriveTB/psf")
  openResults("/home/mseminario2/chips/castalia/ic/.simulation/castalia/tb_anatop_ctrl_amp_ab/maestro/results/maestro/Interactive.168/4/CellDriveTB/psf")
  when(member('stb results())
    selectResult('stb)
    mtxP = outfile("/home/mseminario2/vestarv/implementations/asic/castalia/analog/data/raw/cab_cell_stb__sf.meta" "w")
    fprintf(mtxP "sweep %%L\n" car(errset(sweepNames())))
    close(mtxP)
    errset(mtxDump("/home/mseminario2/vestarv/implementations/asic/castalia/analog/data/raw/cab_cell_stb__sf__cell_aol_db.csv" ymax(dB20(getData("loopGain" ?result "stb")))))
    errset(mtxDump("/home/mseminario2/vestarv/implementations/asic/castalia/analog/data/raw/cab_cell_stb__sf__cell_pm.csv" value(phase(getData("loopGain" ?result "stb")) cross(dB20(getData("loopGain" ?result "stb")) 0 1 "falling"))))
    errset(mtxDump("/home/mseminario2/vestarv/implementations/asic/castalia/analog/data/raw/cab_cell_stb__sf__cell_ugf.csv" cross(dB20(getData("loopGain" ?result "stb")) 0 1 "falling")))
  )
)

;; ---- corner 4 (sf) / test cab_drive_dc
when(isDir("/home/mseminario2/chips/castalia/ic/.simulation/castalia/tb_anatop_ctrl_amp_ab/maestro/results/maestro/Interactive.168/4/DriveTB/psf")
  openResults("/home/mseminario2/chips/castalia/ic/.simulation/castalia/tb_anatop_ctrl_amp_ab/maestro/results/maestro/Interactive.168/4/DriveTB/psf")
  when(member('dc results())
    selectResult('dc)
    mtxP = outfile("/home/mseminario2/vestarv/implementations/asic/castalia/analog/data/raw/cab_drive_dc__sf.meta" "w")
    fprintf(mtxP "sweep %%L\n" car(errset(sweepNames())))
    close(mtxP)
    errset(mtxDump("/home/mseminario2/vestarv/implementations/asic/castalia/analog/data/raw/cab_drive_dc__sf__Rout_cl.csv" abs(value(deriv(VS("/V_OutOL")) 0))))
    errset(mtxDump("/home/mseminario2/vestarv/implementations/asic/castalia/analog/data/raw/cab_drive_dc__sf__i_sink_50m.csv" cross(abs((VS("/V_OutOL") - VAR("V_CM"))) 0.05 1 "falling")))
    errset(mtxDump("/home/mseminario2/vestarv/implementations/asic/castalia/analog/data/raw/cab_drive_dc__sf__i_src_50m.csv" cross(abs((VS("/V_OutOL") - VAR("V_CM"))) 0.05 1 "rising")))
  )
)

;; ---- corner 4 (sf) / test cab_offset_dc
when(isDir("/home/mseminario2/chips/castalia/ic/.simulation/castalia/tb_anatop_ctrl_amp_ab/maestro/results/maestro/Interactive.168/4/OffsetCalTB/psf")
  openResults("/home/mseminario2/chips/castalia/ic/.simulation/castalia/tb_anatop_ctrl_amp_ab/maestro/results/maestro/Interactive.168/4/OffsetCalTB/psf")
  when(member('dc results())
    selectResult('dc)
    mtxP = outfile("/home/mseminario2/vestarv/implementations/asic/castalia/analog/data/raw/cab_offset_dc__sf.meta" "w")
    fprintf(mtxP "sweep %%L\n" car(errset(sweepNames())))
    close(mtxP)
    errset(mtxDump("/home/mseminario2/vestarv/implementations/asic/castalia/analog/data/raw/cab_offset_dc__sf__vos.csv" cross(VS("/V_OutOL") (VAR("VDD25") / 2) 1 "either" nil nil nil)))
  )
)

;; ---- corner 4 (sf) / test cab_ol_ac
when(isDir("/home/mseminario2/chips/castalia/ic/.simulation/castalia/tb_anatop_ctrl_amp_ab/maestro/results/maestro/Interactive.168/4/TypOpenLoopTB/psf")
  openResults("/home/mseminario2/chips/castalia/ic/.simulation/castalia/tb_anatop_ctrl_amp_ab/maestro/results/maestro/Interactive.168/4/TypOpenLoopTB/psf")
  when(member('ac results())
    selectResult('ac)
    mtxP = outfile("/home/mseminario2/vestarv/implementations/asic/castalia/analog/data/raw/cab_ol_ac__sf.meta" "w")
    fprintf(mtxP "sweep %%L\n" car(errset(sweepNames())))
    close(mtxP)
    errset(mtxDump("/home/mseminario2/vestarv/implementations/asic/castalia/analog/data/raw/cab_ol_ac__sf__ol_f3db.csv" bandwidth((VF("/V_OutOL") / (VF("/V_InP") - VF("/V_InM"))) 3 "low")))
    errset(mtxDump("/home/mseminario2/vestarv/implementations/asic/castalia/analog/data/raw/cab_ol_ac__sf__ol_fu.csv" unityGainFreq((VF("/V_OutOL") / (VF("/V_InP") - VF("/V_InM"))))))
    errset(mtxDump("/home/mseminario2/vestarv/implementations/asic/castalia/analog/data/raw/cab_ol_ac__sf__ol_gain_db.csv" dB20(ymax(mag((VF("/V_OutOL") / (VF("/V_InP") - VF("/V_InM"))))))))
    errset(mtxDump("/home/mseminario2/vestarv/implementations/asic/castalia/analog/data/raw/cab_ol_ac__sf__ol_pm.csv" phaseMargin((VF("/V_OutOL") / (VF("/V_InP") - VF("/V_InM"))))))
  )
)

;; ---- corner 4 (sf) / test cab_ol_dcop
when(isDir("/home/mseminario2/chips/castalia/ic/.simulation/castalia/tb_anatop_ctrl_amp_ab/maestro/results/maestro/Interactive.168/4/TypOpenLoopTB/psf")
  openResults("/home/mseminario2/chips/castalia/ic/.simulation/castalia/tb_anatop_ctrl_amp_ab/maestro/results/maestro/Interactive.168/4/TypOpenLoopTB/psf")
  when(member('dcOp results())
    selectResult('dcOp)
    mtxP = outfile("/home/mseminario2/vestarv/implementations/asic/castalia/analog/data/raw/cab_ol_dcop__sf.meta" "w")
    fprintf(mtxP "sweep %%L\n" car(errset(sweepNames())))
    close(mtxP)
    errset(mtxDump("/home/mseminario2/vestarv/implementations/asic/castalia/analog/data/raw/cab_ol_dcop__sf__ol_itot.csv" abs(IDC("/POWER/SRC_VDD25/PLUS"))))
    errset(mtxDump("/home/mseminario2/vestarv/implementations/asic/castalia/analog/data/raw/cab_ol_dcop__sf__ol_ptot.csv" (abs(IDC("/POWER/SRC_VDD25/PLUS")) * VAR("VDD25"))))
  )
)

;; ---- corner 4 (sf) / test cab_unity_stb
when(isDir("/home/mseminario2/chips/castalia/ic/.simulation/castalia/tb_anatop_ctrl_amp_ab/maestro/results/maestro/Interactive.168/4/UnityFeedbackTB/psf")
  openResults("/home/mseminario2/chips/castalia/ic/.simulation/castalia/tb_anatop_ctrl_amp_ab/maestro/results/maestro/Interactive.168/4/UnityFeedbackTB/psf")
  when(member('stb results())
    selectResult('stb)
    mtxP = outfile("/home/mseminario2/vestarv/implementations/asic/castalia/analog/data/raw/cab_unity_stb__sf.meta" "w")
    fprintf(mtxP "sweep %%L\n" car(errset(sweepNames())))
    close(mtxP)
    errset(mtxDump("/home/mseminario2/vestarv/implementations/asic/castalia/analog/data/raw/cab_unity_stb__sf__uf_aol_db.csv" ymax(dB20(getData("loopGain" ?result "stb")))))
    errset(mtxDump("/home/mseminario2/vestarv/implementations/asic/castalia/analog/data/raw/cab_unity_stb__sf__uf_gm.csv" (- value(dB20(getData("loopGain" ?result "stb")) cross(phase(getData("loopGain" ?result "stb")) 0 1 "falling")))))
    errset(mtxDump("/home/mseminario2/vestarv/implementations/asic/castalia/analog/data/raw/cab_unity_stb__sf__uf_pm.csv" value(phase(getData("loopGain" ?result "stb")) cross(dB20(getData("loopGain" ?result "stb")) 0 1 "falling"))))
    errset(mtxDump("/home/mseminario2/vestarv/implementations/asic/castalia/analog/data/raw/cab_unity_stb__sf__uf_ugf.csv" cross(dB20(getData("loopGain" ?result "stb")) 0 1 "falling")))
  )
)

;; ---- corner 5 (ss) / test cab_cell_dc
when(isDir("/home/mseminario2/chips/castalia/ic/.simulation/castalia/tb_anatop_ctrl_amp_ab/maestro/results/maestro/Interactive.168/5/CellDriveTB/psf")
  openResults("/home/mseminario2/chips/castalia/ic/.simulation/castalia/tb_anatop_ctrl_amp_ab/maestro/results/maestro/Interactive.168/5/CellDriveTB/psf")
  when(member('dc results())
    selectResult('dc)
    mtxP = outfile("/home/mseminario2/vestarv/implementations/asic/castalia/analog/data/raw/cab_cell_dc__ss.meta" "w")
    fprintf(mtxP "sweep %%L\n" car(errset(sweepNames())))
    close(mtxP)
    errset(mtxDump("/home/mseminario2/vestarv/implementations/asic/castalia/analog/data/raw/cab_cell_dc__ss__ce_hi.csv" ymax(VS("/CE"))))
    errset(mtxDump("/home/mseminario2/vestarv/implementations/asic/castalia/analog/data/raw/cab_cell_dc__ss__ce_lo.csv" ymin(VS("/CE"))))
    errset(mtxDump("/home/mseminario2/vestarv/implementations/asic/castalia/analog/data/raw/cab_cell_dc__ss__ce_w.csv" VS("/CE")))
    errset(mtxDump("/home/mseminario2/vestarv/implementations/asic/castalia/analog/data/raw/cab_cell_dc__ss__i_sink_max.csv" abs(ymin(IS("/SRC_WE/PLUS")))))
    errset(mtxDump("/home/mseminario2/vestarv/implementations/asic/castalia/analog/data/raw/cab_cell_dc__ss__i_src_max.csv" ymax(IS("/SRC_WE/PLUS"))))
    errset(mtxDump("/home/mseminario2/vestarv/implementations/asic/castalia/analog/data/raw/cab_cell_dc__ss__re_err_0.csv" value((VS("/RE") - xval(VS("/RE"))) VAR("V_CM"))))
    errset(mtxDump("/home/mseminario2/vestarv/implementations/asic/castalia/analog/data/raw/cab_cell_dc__ss__re_err_max.csv" ymax(abs(clip((VS("/RE") - xval(VS("/RE"))) VAR("vref_lo") VAR("vref_hi"))))))
    errset(mtxDump("/home/mseminario2/vestarv/implementations/asic/castalia/analog/data/raw/cab_cell_dc__ss__re_err_slope.csv" ymax(abs(deriv(clip((VS("/RE") - xval(VS("/RE"))) VAR("vref_lo") VAR("vref_hi")))))))
    errset(mtxDump("/home/mseminario2/vestarv/implementations/asic/castalia/analog/data/raw/cab_cell_dc__ss__re_reg_n10.csv" (value((VS("/RE") - xval(VS("/RE"))) cross(IS("/SRC_WE/PLUS") -1e-05 1 "either")) - value((VS("/RE") - xval(VS("/RE"))) VAR("V_CM")))))
    errset(mtxDump("/home/mseminario2/vestarv/implementations/asic/castalia/analog/data/raw/cab_cell_dc__ss__re_reg_p10.csv" (value((VS("/RE") - xval(VS("/RE"))) cross(IS("/SRC_WE/PLUS") 1e-05 1 "either")) - value((VS("/RE") - xval(VS("/RE"))) VAR("V_CM")))))
  )
)

;; ---- corner 5 (ss) / test cab_cell_stb
when(isDir("/home/mseminario2/chips/castalia/ic/.simulation/castalia/tb_anatop_ctrl_amp_ab/maestro/results/maestro/Interactive.168/5/CellDriveTB/psf")
  openResults("/home/mseminario2/chips/castalia/ic/.simulation/castalia/tb_anatop_ctrl_amp_ab/maestro/results/maestro/Interactive.168/5/CellDriveTB/psf")
  when(member('stb results())
    selectResult('stb)
    mtxP = outfile("/home/mseminario2/vestarv/implementations/asic/castalia/analog/data/raw/cab_cell_stb__ss.meta" "w")
    fprintf(mtxP "sweep %%L\n" car(errset(sweepNames())))
    close(mtxP)
    errset(mtxDump("/home/mseminario2/vestarv/implementations/asic/castalia/analog/data/raw/cab_cell_stb__ss__cell_aol_db.csv" ymax(dB20(getData("loopGain" ?result "stb")))))
    errset(mtxDump("/home/mseminario2/vestarv/implementations/asic/castalia/analog/data/raw/cab_cell_stb__ss__cell_pm.csv" value(phase(getData("loopGain" ?result "stb")) cross(dB20(getData("loopGain" ?result "stb")) 0 1 "falling"))))
    errset(mtxDump("/home/mseminario2/vestarv/implementations/asic/castalia/analog/data/raw/cab_cell_stb__ss__cell_ugf.csv" cross(dB20(getData("loopGain" ?result "stb")) 0 1 "falling")))
  )
)

;; ---- corner 5 (ss) / test cab_drive_dc
when(isDir("/home/mseminario2/chips/castalia/ic/.simulation/castalia/tb_anatop_ctrl_amp_ab/maestro/results/maestro/Interactive.168/5/DriveTB/psf")
  openResults("/home/mseminario2/chips/castalia/ic/.simulation/castalia/tb_anatop_ctrl_amp_ab/maestro/results/maestro/Interactive.168/5/DriveTB/psf")
  when(member('dc results())
    selectResult('dc)
    mtxP = outfile("/home/mseminario2/vestarv/implementations/asic/castalia/analog/data/raw/cab_drive_dc__ss.meta" "w")
    fprintf(mtxP "sweep %%L\n" car(errset(sweepNames())))
    close(mtxP)
    errset(mtxDump("/home/mseminario2/vestarv/implementations/asic/castalia/analog/data/raw/cab_drive_dc__ss__Rout_cl.csv" abs(value(deriv(VS("/V_OutOL")) 0))))
    errset(mtxDump("/home/mseminario2/vestarv/implementations/asic/castalia/analog/data/raw/cab_drive_dc__ss__i_sink_50m.csv" cross(abs((VS("/V_OutOL") - VAR("V_CM"))) 0.05 1 "falling")))
    errset(mtxDump("/home/mseminario2/vestarv/implementations/asic/castalia/analog/data/raw/cab_drive_dc__ss__i_src_50m.csv" cross(abs((VS("/V_OutOL") - VAR("V_CM"))) 0.05 1 "rising")))
  )
)

;; ---- corner 5 (ss) / test cab_offset_dc
when(isDir("/home/mseminario2/chips/castalia/ic/.simulation/castalia/tb_anatop_ctrl_amp_ab/maestro/results/maestro/Interactive.168/5/OffsetCalTB/psf")
  openResults("/home/mseminario2/chips/castalia/ic/.simulation/castalia/tb_anatop_ctrl_amp_ab/maestro/results/maestro/Interactive.168/5/OffsetCalTB/psf")
  when(member('dc results())
    selectResult('dc)
    mtxP = outfile("/home/mseminario2/vestarv/implementations/asic/castalia/analog/data/raw/cab_offset_dc__ss.meta" "w")
    fprintf(mtxP "sweep %%L\n" car(errset(sweepNames())))
    close(mtxP)
    errset(mtxDump("/home/mseminario2/vestarv/implementations/asic/castalia/analog/data/raw/cab_offset_dc__ss__vos.csv" cross(VS("/V_OutOL") (VAR("VDD25") / 2) 1 "either" nil nil nil)))
  )
)

;; ---- corner 5 (ss) / test cab_ol_ac
when(isDir("/home/mseminario2/chips/castalia/ic/.simulation/castalia/tb_anatop_ctrl_amp_ab/maestro/results/maestro/Interactive.168/5/TypOpenLoopTB/psf")
  openResults("/home/mseminario2/chips/castalia/ic/.simulation/castalia/tb_anatop_ctrl_amp_ab/maestro/results/maestro/Interactive.168/5/TypOpenLoopTB/psf")
  when(member('ac results())
    selectResult('ac)
    mtxP = outfile("/home/mseminario2/vestarv/implementations/asic/castalia/analog/data/raw/cab_ol_ac__ss.meta" "w")
    fprintf(mtxP "sweep %%L\n" car(errset(sweepNames())))
    close(mtxP)
    errset(mtxDump("/home/mseminario2/vestarv/implementations/asic/castalia/analog/data/raw/cab_ol_ac__ss__ol_f3db.csv" bandwidth((VF("/V_OutOL") / (VF("/V_InP") - VF("/V_InM"))) 3 "low")))
    errset(mtxDump("/home/mseminario2/vestarv/implementations/asic/castalia/analog/data/raw/cab_ol_ac__ss__ol_fu.csv" unityGainFreq((VF("/V_OutOL") / (VF("/V_InP") - VF("/V_InM"))))))
    errset(mtxDump("/home/mseminario2/vestarv/implementations/asic/castalia/analog/data/raw/cab_ol_ac__ss__ol_gain_db.csv" dB20(ymax(mag((VF("/V_OutOL") / (VF("/V_InP") - VF("/V_InM"))))))))
    errset(mtxDump("/home/mseminario2/vestarv/implementations/asic/castalia/analog/data/raw/cab_ol_ac__ss__ol_pm.csv" phaseMargin((VF("/V_OutOL") / (VF("/V_InP") - VF("/V_InM"))))))
  )
)

;; ---- corner 5 (ss) / test cab_ol_dcop
when(isDir("/home/mseminario2/chips/castalia/ic/.simulation/castalia/tb_anatop_ctrl_amp_ab/maestro/results/maestro/Interactive.168/5/TypOpenLoopTB/psf")
  openResults("/home/mseminario2/chips/castalia/ic/.simulation/castalia/tb_anatop_ctrl_amp_ab/maestro/results/maestro/Interactive.168/5/TypOpenLoopTB/psf")
  when(member('dcOp results())
    selectResult('dcOp)
    mtxP = outfile("/home/mseminario2/vestarv/implementations/asic/castalia/analog/data/raw/cab_ol_dcop__ss.meta" "w")
    fprintf(mtxP "sweep %%L\n" car(errset(sweepNames())))
    close(mtxP)
    errset(mtxDump("/home/mseminario2/vestarv/implementations/asic/castalia/analog/data/raw/cab_ol_dcop__ss__ol_itot.csv" abs(IDC("/POWER/SRC_VDD25/PLUS"))))
    errset(mtxDump("/home/mseminario2/vestarv/implementations/asic/castalia/analog/data/raw/cab_ol_dcop__ss__ol_ptot.csv" (abs(IDC("/POWER/SRC_VDD25/PLUS")) * VAR("VDD25"))))
  )
)

;; ---- corner 5 (ss) / test cab_unity_stb
when(isDir("/home/mseminario2/chips/castalia/ic/.simulation/castalia/tb_anatop_ctrl_amp_ab/maestro/results/maestro/Interactive.168/5/UnityFeedbackTB/psf")
  openResults("/home/mseminario2/chips/castalia/ic/.simulation/castalia/tb_anatop_ctrl_amp_ab/maestro/results/maestro/Interactive.168/5/UnityFeedbackTB/psf")
  when(member('stb results())
    selectResult('stb)
    mtxP = outfile("/home/mseminario2/vestarv/implementations/asic/castalia/analog/data/raw/cab_unity_stb__ss.meta" "w")
    fprintf(mtxP "sweep %%L\n" car(errset(sweepNames())))
    close(mtxP)
    errset(mtxDump("/home/mseminario2/vestarv/implementations/asic/castalia/analog/data/raw/cab_unity_stb__ss__uf_aol_db.csv" ymax(dB20(getData("loopGain" ?result "stb")))))
    errset(mtxDump("/home/mseminario2/vestarv/implementations/asic/castalia/analog/data/raw/cab_unity_stb__ss__uf_gm.csv" (- value(dB20(getData("loopGain" ?result "stb")) cross(phase(getData("loopGain" ?result "stb")) 0 1 "falling")))))
    errset(mtxDump("/home/mseminario2/vestarv/implementations/asic/castalia/analog/data/raw/cab_unity_stb__ss__uf_pm.csv" value(phase(getData("loopGain" ?result "stb")) cross(dB20(getData("loopGain" ?result "stb")) 0 1 "falling"))))
    errset(mtxDump("/home/mseminario2/vestarv/implementations/asic/castalia/analog/data/raw/cab_unity_stb__ss__uf_ugf.csv" cross(dB20(getData("loopGain" ?result "stb")) 0 1 "falling")))
  )
)

printf("MTX_EXTRACT_DONE\n")
exit(0)
