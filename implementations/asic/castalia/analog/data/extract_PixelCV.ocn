;; generated by maestro2tex -- do not edit
procedure(mtxDump(fname wv)
  let((xs ys n p)
    p = outfile(fname "w")
    cond(
      (null(wv) fprintf(p "#nil\n"))
      (drIsWaveform(wv)
        xs = drGetWaveformXVec(wv)
        ys = drGetWaveformYVec(wv)
        n = drVectorLength(xs)
        for(i 0 n-1
          fprintf(p "%.10g %.10g\n" drGetElem(xs i) drGetElem(ys i)))
      )
      (t fprintf(p "#scalar %.10g\n" float(wv)))
    )
    close(p)
    t))

;; ---- corner 1 (tt) / test px_cv_tran
when(isDir("/home/mseminario2/chips/castalia/simruns/tb_anatop_pixel_cv_1M/castalia/tb_anatop_pixel/maestro/results/maestro/Ocean.0/1/ps_cv/psf")
  openResults("/home/mseminario2/chips/castalia/simruns/tb_anatop_pixel_cv_1M/castalia/tb_anatop_pixel/maestro/results/maestro/Ocean.0/1/ps_cv/psf")
  when(member('tran results())
    selectResult('tran)
    mtxP = outfile("/home/mseminario2/vestarv/implementations/asic/castalia/analog/data/raw/px_cv_tran__tt.meta" "w")
    fprintf(mtxP "sweep %%L\n" car(errset(sweepNames())))
    close(mtxP)
    errset(mtxDump("/home/mseminario2/vestarv/implementations/asic/castalia/analog/data/raw/px_cv_tran__tt__cv_i.csv" ((VT("/V_OUT") - VAR("V_CM")) / VAR("rf"))))
    errset(mtxDump("/home/mseminario2/vestarv/implementations/asic/castalia/analog/data/raw/px_cv_tran__tt__cv_x.csv" VT("/RE")))
  )
)

printf("MTX_EXTRACT_DONE\n")
exit(0)
