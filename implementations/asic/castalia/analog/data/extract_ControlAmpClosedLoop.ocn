;; generated by maestro2tex -- do not edit
procedure(mtxDump(fname wv)
  let((xs ys n p)
    p = outfile(fname "w")
    cond(
      (null(wv) fprintf(p "#nil\n"))
      (drIsWaveform(wv)
        xs = drGetWaveformXVec(wv)
        ys = drGetWaveformYVec(wv)
        n = drVectorLength(xs)
        for(i 0 n-1
          fprintf(p "%.10g %.10g\n" drGetElem(xs i) drGetElem(ys i)))
      )
      (t fprintf(p "#scalar %.10g\n" float(wv)))
    )
    close(p)
    t))

;; ---- corner 131 (tt) / test slew
when(isDir("/home/mseminario2/chips/castalia/simarchive/anatop_tb_controlamp/Interactive.137/131/SlewOpenLoopWBiasTB/psf")
  openResults("/home/mseminario2/chips/castalia/simarchive/anatop_tb_controlamp/Interactive.137/131/SlewOpenLoopWBiasTB/psf")
  when(member('tran results())
    selectResult('tran)
    mtxP = outfile("/home/mseminario2/vestarv/implementations/asic/castalia/analog/data/raw/slew__tt.meta" "w")
    fprintf(mtxP "sweep %%L\n" car(errset(sweepNames())))
    close(mtxP)
    errset(mtxDump("/home/mseminario2/vestarv/implementations/asic/castalia/analog/data/raw/slew__tt__iload.csv" i("/C_L/PLUS")))
    errset(mtxDump("/home/mseminario2/vestarv/implementations/asic/castalia/analog/data/raw/slew__tt__ipk_snk.csv" abs(ymin(i("/C_L/PLUS")))))
    errset(mtxDump("/home/mseminario2/vestarv/implementations/asic/castalia/analog/data/raw/slew__tt__ipk_src.csv" ymax(i("/C_L/PLUS"))))
    errset(mtxDump("/home/mseminario2/vestarv/implementations/asic/castalia/analog/data/raw/slew__tt__isnk.csv" abs(average(clip(i("/C_L/PLUS") cross(v("/V_OutOL") 2.25 1 "falling") cross(v("/V_OutOL") 1.25 1 "falling"))))))
    errset(mtxDump("/home/mseminario2/vestarv/implementations/asic/castalia/analog/data/raw/slew__tt__isrc.csv" average(clip(i("/C_L/PLUS") cross(v("/V_OutOL") 1.25 1 "rising") cross(v("/V_OutOL") 2.25 1 "rising")))))
    errset(mtxDump("/home/mseminario2/vestarv/implementations/asic/castalia/analog/data/raw/slew__tt__sr_dn.csv" 1.0/(cross(v("/V_OutOL") 1.25 1 "falling")-cross(v("/V_OutOL") 2.25 1 "falling"))))
    errset(mtxDump("/home/mseminario2/vestarv/implementations/asic/castalia/analog/data/raw/slew__tt__sr_up.csv" 1.0/(cross(v("/V_OutOL") 2.25 1 "rising")-cross(v("/V_OutOL") 1.25 1 "rising"))))
    errset(mtxDump("/home/mseminario2/vestarv/implementations/asic/castalia/analog/data/raw/slew__tt__vin.csv" v("/V_InP")))
    errset(mtxDump("/home/mseminario2/vestarv/implementations/asic/castalia/analog/data/raw/slew__tt__vout.csv" v("/V_OutOL")))
  )
)

;; ---- corner 131 (tt) / test uf_dc
when(isDir("/home/mseminario2/chips/castalia/simarchive/anatop_tb_controlamp/Interactive.137/131/UnityFeedbackWBiasTB/psf")
  openResults("/home/mseminario2/chips/castalia/simarchive/anatop_tb_controlamp/Interactive.137/131/UnityFeedbackWBiasTB/psf")
  when(member('dc results())
    selectResult('dc)
    mtxP = outfile("/home/mseminario2/vestarv/implementations/asic/castalia/analog/data/raw/uf_dc__tt.meta" "w")
    fprintf(mtxP "sweep %%L\n" car(errset(sweepNames())))
    close(mtxP)
    errset(mtxDump("/home/mseminario2/vestarv/implementations/asic/castalia/analog/data/raw/uf_dc__tt__idd.csv" abs(i("/POWER/SRC_VDD25/PLUS"))))
    errset(mtxDump("/home/mseminario2/vestarv/implementations/asic/castalia/analog/data/raw/uf_dc__tt__verr.csv" (v("/V_OutOL")-v("/V_InP"))))
    errset(mtxDump("/home/mseminario2/vestarv/implementations/asic/castalia/analog/data/raw/uf_dc__tt__vin_hi.csv" cross(abs(v("/V_OutOL")-v("/V_InP")) 1e-3 1 "rising")))
    errset(mtxDump("/home/mseminario2/vestarv/implementations/asic/castalia/analog/data/raw/uf_dc__tt__vin_lo.csv" cross(abs(v("/V_OutOL")-v("/V_InP")) 1e-3 1 "falling")))
    errset(mtxDump("/home/mseminario2/vestarv/implementations/asic/castalia/analog/data/raw/uf_dc__tt__vos.csv" value(v("/V_OutOL")-v("/V_InP") 1.25)))
    errset(mtxDump("/home/mseminario2/vestarv/implementations/asic/castalia/analog/data/raw/uf_dc__tt__vout.csv" v("/V_OutOL")))
  )
)

;; ---- corner 131 (tt) / test uf_margin
when(isDir("/home/mseminario2/chips/castalia/simarchive/anatop_tb_controlamp/Interactive.137/131/UnityFeedbackWBiasTB/psf")
  openResults("/home/mseminario2/chips/castalia/simarchive/anatop_tb_controlamp/Interactive.137/131/UnityFeedbackWBiasTB/psf")
  when(member('stb_margin results())
    selectResult('stb_margin)
    mtxP = outfile("/home/mseminario2/vestarv/implementations/asic/castalia/analog/data/raw/uf_margin__tt.meta" "w")
    fprintf(mtxP "sweep %%L\n" car(errset(sweepNames())))
    close(mtxP)
    errset(mtxDump("/home/mseminario2/vestarv/implementations/asic/castalia/analog/data/raw/uf_margin__tt__gm.csv" getData("gainMargin" ?result "stb_margin")))
    errset(mtxDump("/home/mseminario2/vestarv/implementations/asic/castalia/analog/data/raw/uf_margin__tt__gmf.csv" getData("gainMarginFreq" ?result "stb_margin")))
    errset(mtxDump("/home/mseminario2/vestarv/implementations/asic/castalia/analog/data/raw/uf_margin__tt__lg0_db.csv" dB20(value(getData("loopGain" ?result "stb") 1.0))))
    errset(mtxDump("/home/mseminario2/vestarv/implementations/asic/castalia/analog/data/raw/uf_margin__tt__lg_ugf.csv" unityGainFreq(getData("loopGain" ?result "stb"))))
    errset(mtxDump("/home/mseminario2/vestarv/implementations/asic/castalia/analog/data/raw/uf_margin__tt__pm.csv" getData("phaseMargin" ?result "stb_margin")))
    errset(mtxDump("/home/mseminario2/vestarv/implementations/asic/castalia/analog/data/raw/uf_margin__tt__pmf.csv" getData("phaseMarginFreq" ?result "stb_margin")))
  )
)

;; ---- corner 131 (tt) / test uf_noise
when(isDir("/home/mseminario2/chips/castalia/simarchive/anatop_tb_controlamp/Interactive.137/131/UnityFeedbackWBiasTB/psf")
  openResults("/home/mseminario2/chips/castalia/simarchive/anatop_tb_controlamp/Interactive.137/131/UnityFeedbackWBiasTB/psf")
  when(member('noise results())
    selectResult('noise)
    mtxP = outfile("/home/mseminario2/vestarv/implementations/asic/castalia/analog/data/raw/uf_noise__tt.meta" "w")
    fprintf(mtxP "sweep %%L\n" car(errset(sweepNames())))
    close(mtxP)
    errset(mtxDump("/home/mseminario2/vestarv/implementations/asic/castalia/analog/data/raw/uf_noise__tt__fcorner.csv" cross(getData("out") sqrt(2)*value(getData("out") 3e5) 1 "either")))
    errset(mtxDump("/home/mseminario2/vestarv/implementations/asic/castalia/analog/data/raw/uf_noise__tt__nfloor.csv" value(getData("out") 3e5)))
    errset(mtxDump("/home/mseminario2/vestarv/implementations/asic/castalia/analog/data/raw/uf_noise__tt__nint_10k.csv" sqrt(integ(getData("out")**2 0.1 1e4))))
    errset(mtxDump("/home/mseminario2/vestarv/implementations/asic/castalia/analog/data/raw/uf_noise__tt__nint_1M.csv" sqrt(integ(getData("out")**2 0.1 1e6))))
    errset(mtxDump("/home/mseminario2/vestarv/implementations/asic/castalia/analog/data/raw/uf_noise__tt__nout.csv" getData("out")))
    errset(mtxDump("/home/mseminario2/vestarv/implementations/asic/castalia/analog/data/raw/uf_noise__tt__nout_1.csv" value(getData("out") 1.0)))
    errset(mtxDump("/home/mseminario2/vestarv/implementations/asic/castalia/analog/data/raw/uf_noise__tt__nout_1k.csv" value(getData("out") 1e3)))
  )
)

;; ---- corner 131 (tt) / test uf_op
when(isDir("/home/mseminario2/chips/castalia/simarchive/anatop_tb_controlamp/Interactive.137/131/UnityFeedbackWBiasTB/psf")
  openResults("/home/mseminario2/chips/castalia/simarchive/anatop_tb_controlamp/Interactive.137/131/UnityFeedbackWBiasTB/psf")
  when(member('dcOp results())
    selectResult('dcOp)
    mtxP = outfile("/home/mseminario2/vestarv/implementations/asic/castalia/analog/data/raw/uf_op__tt.meta" "w")
    fprintf(mtxP "sweep %%L\n" car(errset(sweepNames())))
    close(mtxP)
    errset(mtxDump("/home/mseminario2/vestarv/implementations/asic/castalia/analog/data/raw/uf_op__tt__iamp.csv" abs(i("/OPAMP/vdd!"))))
    errset(mtxDump("/home/mseminario2/vestarv/implementations/asic/castalia/analog/data/raw/uf_op__tt__itot.csv" abs(i("/POWER/SRC_VDD25/PLUS"))))
    errset(mtxDump("/home/mseminario2/vestarv/implementations/asic/castalia/analog/data/raw/uf_op__tt__vbnc.csv" v("/V_BNC")))
    errset(mtxDump("/home/mseminario2/vestarv/implementations/asic/castalia/analog/data/raw/uf_op__tt__vbnm.csv" v("/V_BNM")))
    errset(mtxDump("/home/mseminario2/vestarv/implementations/asic/castalia/analog/data/raw/uf_op__tt__vbpc.csv" v("/V_BPC")))
    errset(mtxDump("/home/mseminario2/vestarv/implementations/asic/castalia/analog/data/raw/uf_op__tt__vbpm.csv" v("/V_BPM")))
    errset(mtxDump("/home/mseminario2/vestarv/implementations/asic/castalia/analog/data/raw/uf_op__tt__vout_op.csv" v("/V_OutOL")))
  )
)

;; ---- corner 132 (ff) / test slew
when(isDir("/home/mseminario2/chips/castalia/simarchive/anatop_tb_controlamp/Interactive.137/132/SlewOpenLoopWBiasTB/psf")
  openResults("/home/mseminario2/chips/castalia/simarchive/anatop_tb_controlamp/Interactive.137/132/SlewOpenLoopWBiasTB/psf")
  when(member('tran results())
    selectResult('tran)
    mtxP = outfile("/home/mseminario2/vestarv/implementations/asic/castalia/analog/data/raw/slew__ff.meta" "w")
    fprintf(mtxP "sweep %%L\n" car(errset(sweepNames())))
    close(mtxP)
    errset(mtxDump("/home/mseminario2/vestarv/implementations/asic/castalia/analog/data/raw/slew__ff__iload.csv" i("/C_L/PLUS")))
    errset(mtxDump("/home/mseminario2/vestarv/implementations/asic/castalia/analog/data/raw/slew__ff__ipk_snk.csv" abs(ymin(i("/C_L/PLUS")))))
    errset(mtxDump("/home/mseminario2/vestarv/implementations/asic/castalia/analog/data/raw/slew__ff__ipk_src.csv" ymax(i("/C_L/PLUS"))))
    errset(mtxDump("/home/mseminario2/vestarv/implementations/asic/castalia/analog/data/raw/slew__ff__isnk.csv" abs(average(clip(i("/C_L/PLUS") cross(v("/V_OutOL") 2.25 1 "falling") cross(v("/V_OutOL") 1.25 1 "falling"))))))
    errset(mtxDump("/home/mseminario2/vestarv/implementations/asic/castalia/analog/data/raw/slew__ff__isrc.csv" average(clip(i("/C_L/PLUS") cross(v("/V_OutOL") 1.25 1 "rising") cross(v("/V_OutOL") 2.25 1 "rising")))))
    errset(mtxDump("/home/mseminario2/vestarv/implementations/asic/castalia/analog/data/raw/slew__ff__sr_dn.csv" 1.0/(cross(v("/V_OutOL") 1.25 1 "falling")-cross(v("/V_OutOL") 2.25 1 "falling"))))
    errset(mtxDump("/home/mseminario2/vestarv/implementations/asic/castalia/analog/data/raw/slew__ff__sr_up.csv" 1.0/(cross(v("/V_OutOL") 2.25 1 "rising")-cross(v("/V_OutOL") 1.25 1 "rising"))))
    errset(mtxDump("/home/mseminario2/vestarv/implementations/asic/castalia/analog/data/raw/slew__ff__vin.csv" v("/V_InP")))
    errset(mtxDump("/home/mseminario2/vestarv/implementations/asic/castalia/analog/data/raw/slew__ff__vout.csv" v("/V_OutOL")))
  )
)

;; ---- corner 132 (ff) / test uf_dc
when(isDir("/home/mseminario2/chips/castalia/simarchive/anatop_tb_controlamp/Interactive.137/132/UnityFeedbackWBiasTB/psf")
  openResults("/home/mseminario2/chips/castalia/simarchive/anatop_tb_controlamp/Interactive.137/132/UnityFeedbackWBiasTB/psf")
  when(member('dc results())
    selectResult('dc)
    mtxP = outfile("/home/mseminario2/vestarv/implementations/asic/castalia/analog/data/raw/uf_dc__ff.meta" "w")
    fprintf(mtxP "sweep %%L\n" car(errset(sweepNames())))
    close(mtxP)
    errset(mtxDump("/home/mseminario2/vestarv/implementations/asic/castalia/analog/data/raw/uf_dc__ff__idd.csv" abs(i("/POWER/SRC_VDD25/PLUS"))))
    errset(mtxDump("/home/mseminario2/vestarv/implementations/asic/castalia/analog/data/raw/uf_dc__ff__verr.csv" (v("/V_OutOL")-v("/V_InP"))))
    errset(mtxDump("/home/mseminario2/vestarv/implementations/asic/castalia/analog/data/raw/uf_dc__ff__vin_hi.csv" cross(abs(v("/V_OutOL")-v("/V_InP")) 1e-3 1 "rising")))
    errset(mtxDump("/home/mseminario2/vestarv/implementations/asic/castalia/analog/data/raw/uf_dc__ff__vin_lo.csv" cross(abs(v("/V_OutOL")-v("/V_InP")) 1e-3 1 "falling")))
    errset(mtxDump("/home/mseminario2/vestarv/implementations/asic/castalia/analog/data/raw/uf_dc__ff__vos.csv" value(v("/V_OutOL")-v("/V_InP") 1.25)))
    errset(mtxDump("/home/mseminario2/vestarv/implementations/asic/castalia/analog/data/raw/uf_dc__ff__vout.csv" v("/V_OutOL")))
  )
)

;; ---- corner 132 (ff) / test uf_margin
when(isDir("/home/mseminario2/chips/castalia/simarchive/anatop_tb_controlamp/Interactive.137/132/UnityFeedbackWBiasTB/psf")
  openResults("/home/mseminario2/chips/castalia/simarchive/anatop_tb_controlamp/Interactive.137/132/UnityFeedbackWBiasTB/psf")
  when(member('stb_margin results())
    selectResult('stb_margin)
    mtxP = outfile("/home/mseminario2/vestarv/implementations/asic/castalia/analog/data/raw/uf_margin__ff.meta" "w")
    fprintf(mtxP "sweep %%L\n" car(errset(sweepNames())))
    close(mtxP)
    errset(mtxDump("/home/mseminario2/vestarv/implementations/asic/castalia/analog/data/raw/uf_margin__ff__gm.csv" getData("gainMargin" ?result "stb_margin")))
    errset(mtxDump("/home/mseminario2/vestarv/implementations/asic/castalia/analog/data/raw/uf_margin__ff__gmf.csv" getData("gainMarginFreq" ?result "stb_margin")))
    errset(mtxDump("/home/mseminario2/vestarv/implementations/asic/castalia/analog/data/raw/uf_margin__ff__lg0_db.csv" dB20(value(getData("loopGain" ?result "stb") 1.0))))
    errset(mtxDump("/home/mseminario2/vestarv/implementations/asic/castalia/analog/data/raw/uf_margin__ff__lg_ugf.csv" unityGainFreq(getData("loopGain" ?result "stb"))))
    errset(mtxDump("/home/mseminario2/vestarv/implementations/asic/castalia/analog/data/raw/uf_margin__ff__pm.csv" getData("phaseMargin" ?result "stb_margin")))
    errset(mtxDump("/home/mseminario2/vestarv/implementations/asic/castalia/analog/data/raw/uf_margin__ff__pmf.csv" getData("phaseMarginFreq" ?result "stb_margin")))
  )
)

;; ---- corner 132 (ff) / test uf_noise
when(isDir("/home/mseminario2/chips/castalia/simarchive/anatop_tb_controlamp/Interactive.137/132/UnityFeedbackWBiasTB/psf")
  openResults("/home/mseminario2/chips/castalia/simarchive/anatop_tb_controlamp/Interactive.137/132/UnityFeedbackWBiasTB/psf")
  when(member('noise results())
    selectResult('noise)
    mtxP = outfile("/home/mseminario2/vestarv/implementations/asic/castalia/analog/data/raw/uf_noise__ff.meta" "w")
    fprintf(mtxP "sweep %%L\n" car(errset(sweepNames())))
    close(mtxP)
    errset(mtxDump("/home/mseminario2/vestarv/implementations/asic/castalia/analog/data/raw/uf_noise__ff__fcorner.csv" cross(getData("out") sqrt(2)*value(getData("out") 3e5) 1 "either")))
    errset(mtxDump("/home/mseminario2/vestarv/implementations/asic/castalia/analog/data/raw/uf_noise__ff__nfloor.csv" value(getData("out") 3e5)))
    errset(mtxDump("/home/mseminario2/vestarv/implementations/asic/castalia/analog/data/raw/uf_noise__ff__nint_10k.csv" sqrt(integ(getData("out")**2 0.1 1e4))))
    errset(mtxDump("/home/mseminario2/vestarv/implementations/asic/castalia/analog/data/raw/uf_noise__ff__nint_1M.csv" sqrt(integ(getData("out")**2 0.1 1e6))))
    errset(mtxDump("/home/mseminario2/vestarv/implementations/asic/castalia/analog/data/raw/uf_noise__ff__nout.csv" getData("out")))
    errset(mtxDump("/home/mseminario2/vestarv/implementations/asic/castalia/analog/data/raw/uf_noise__ff__nout_1.csv" value(getData("out") 1.0)))
    errset(mtxDump("/home/mseminario2/vestarv/implementations/asic/castalia/analog/data/raw/uf_noise__ff__nout_1k.csv" value(getData("out") 1e3)))
  )
)

;; ---- corner 132 (ff) / test uf_op
when(isDir("/home/mseminario2/chips/castalia/simarchive/anatop_tb_controlamp/Interactive.137/132/UnityFeedbackWBiasTB/psf")
  openResults("/home/mseminario2/chips/castalia/simarchive/anatop_tb_controlamp/Interactive.137/132/UnityFeedbackWBiasTB/psf")
  when(member('dcOp results())
    selectResult('dcOp)
    mtxP = outfile("/home/mseminario2/vestarv/implementations/asic/castalia/analog/data/raw/uf_op__ff.meta" "w")
    fprintf(mtxP "sweep %%L\n" car(errset(sweepNames())))
    close(mtxP)
    errset(mtxDump("/home/mseminario2/vestarv/implementations/asic/castalia/analog/data/raw/uf_op__ff__iamp.csv" abs(i("/OPAMP/vdd!"))))
    errset(mtxDump("/home/mseminario2/vestarv/implementations/asic/castalia/analog/data/raw/uf_op__ff__itot.csv" abs(i("/POWER/SRC_VDD25/PLUS"))))
    errset(mtxDump("/home/mseminario2/vestarv/implementations/asic/castalia/analog/data/raw/uf_op__ff__vbnc.csv" v("/V_BNC")))
    errset(mtxDump("/home/mseminario2/vestarv/implementations/asic/castalia/analog/data/raw/uf_op__ff__vbnm.csv" v("/V_BNM")))
    errset(mtxDump("/home/mseminario2/vestarv/implementations/asic/castalia/analog/data/raw/uf_op__ff__vbpc.csv" v("/V_BPC")))
    errset(mtxDump("/home/mseminario2/vestarv/implementations/asic/castalia/analog/data/raw/uf_op__ff__vbpm.csv" v("/V_BPM")))
    errset(mtxDump("/home/mseminario2/vestarv/implementations/asic/castalia/analog/data/raw/uf_op__ff__vout_op.csv" v("/V_OutOL")))
  )
)

;; ---- corner 133 (fs) / test slew
when(isDir("/home/mseminario2/chips/castalia/simarchive/anatop_tb_controlamp/Interactive.137/133/SlewOpenLoopWBiasTB/psf")
  openResults("/home/mseminario2/chips/castalia/simarchive/anatop_tb_controlamp/Interactive.137/133/SlewOpenLoopWBiasTB/psf")
  when(member('tran results())
    selectResult('tran)
    mtxP = outfile("/home/mseminario2/vestarv/implementations/asic/castalia/analog/data/raw/slew__fs.meta" "w")
    fprintf(mtxP "sweep %%L\n" car(errset(sweepNames())))
    close(mtxP)
    errset(mtxDump("/home/mseminario2/vestarv/implementations/asic/castalia/analog/data/raw/slew__fs__iload.csv" i("/C_L/PLUS")))
    errset(mtxDump("/home/mseminario2/vestarv/implementations/asic/castalia/analog/data/raw/slew__fs__ipk_snk.csv" abs(ymin(i("/C_L/PLUS")))))
    errset(mtxDump("/home/mseminario2/vestarv/implementations/asic/castalia/analog/data/raw/slew__fs__ipk_src.csv" ymax(i("/C_L/PLUS"))))
    errset(mtxDump("/home/mseminario2/vestarv/implementations/asic/castalia/analog/data/raw/slew__fs__isnk.csv" abs(average(clip(i("/C_L/PLUS") cross(v("/V_OutOL") 2.25 1 "falling") cross(v("/V_OutOL") 1.25 1 "falling"))))))
    errset(mtxDump("/home/mseminario2/vestarv/implementations/asic/castalia/analog/data/raw/slew__fs__isrc.csv" average(clip(i("/C_L/PLUS") cross(v("/V_OutOL") 1.25 1 "rising") cross(v("/V_OutOL") 2.25 1 "rising")))))
    errset(mtxDump("/home/mseminario2/vestarv/implementations/asic/castalia/analog/data/raw/slew__fs__sr_dn.csv" 1.0/(cross(v("/V_OutOL") 1.25 1 "falling")-cross(v("/V_OutOL") 2.25 1 "falling"))))
    errset(mtxDump("/home/mseminario2/vestarv/implementations/asic/castalia/analog/data/raw/slew__fs__sr_up.csv" 1.0/(cross(v("/V_OutOL") 2.25 1 "rising")-cross(v("/V_OutOL") 1.25 1 "rising"))))
    errset(mtxDump("/home/mseminario2/vestarv/implementations/asic/castalia/analog/data/raw/slew__fs__vin.csv" v("/V_InP")))
    errset(mtxDump("/home/mseminario2/vestarv/implementations/asic/castalia/analog/data/raw/slew__fs__vout.csv" v("/V_OutOL")))
  )
)

;; ---- corner 133 (fs) / test uf_dc
when(isDir("/home/mseminario2/chips/castalia/simarchive/anatop_tb_controlamp/Interactive.137/133/UnityFeedbackWBiasTB/psf")
  openResults("/home/mseminario2/chips/castalia/simarchive/anatop_tb_controlamp/Interactive.137/133/UnityFeedbackWBiasTB/psf")
  when(member('dc results())
    selectResult('dc)
    mtxP = outfile("/home/mseminario2/vestarv/implementations/asic/castalia/analog/data/raw/uf_dc__fs.meta" "w")
    fprintf(mtxP "sweep %%L\n" car(errset(sweepNames())))
    close(mtxP)
    errset(mtxDump("/home/mseminario2/vestarv/implementations/asic/castalia/analog/data/raw/uf_dc__fs__idd.csv" abs(i("/POWER/SRC_VDD25/PLUS"))))
    errset(mtxDump("/home/mseminario2/vestarv/implementations/asic/castalia/analog/data/raw/uf_dc__fs__verr.csv" (v("/V_OutOL")-v("/V_InP"))))
    errset(mtxDump("/home/mseminario2/vestarv/implementations/asic/castalia/analog/data/raw/uf_dc__fs__vin_hi.csv" cross(abs(v("/V_OutOL")-v("/V_InP")) 1e-3 1 "rising")))
    errset(mtxDump("/home/mseminario2/vestarv/implementations/asic/castalia/analog/data/raw/uf_dc__fs__vin_lo.csv" cross(abs(v("/V_OutOL")-v("/V_InP")) 1e-3 1 "falling")))
    errset(mtxDump("/home/mseminario2/vestarv/implementations/asic/castalia/analog/data/raw/uf_dc__fs__vos.csv" value(v("/V_OutOL")-v("/V_InP") 1.25)))
    errset(mtxDump("/home/mseminario2/vestarv/implementations/asic/castalia/analog/data/raw/uf_dc__fs__vout.csv" v("/V_OutOL")))
  )
)

;; ---- corner 133 (fs) / test uf_margin
when(isDir("/home/mseminario2/chips/castalia/simarchive/anatop_tb_controlamp/Interactive.137/133/UnityFeedbackWBiasTB/psf")
  openResults("/home/mseminario2/chips/castalia/simarchive/anatop_tb_controlamp/Interactive.137/133/UnityFeedbackWBiasTB/psf")
  when(member('stb_margin results())
    selectResult('stb_margin)
    mtxP = outfile("/home/mseminario2/vestarv/implementations/asic/castalia/analog/data/raw/uf_margin__fs.meta" "w")
    fprintf(mtxP "sweep %%L\n" car(errset(sweepNames())))
    close(mtxP)
    errset(mtxDump("/home/mseminario2/vestarv/implementations/asic/castalia/analog/data/raw/uf_margin__fs__gm.csv" getData("gainMargin" ?result "stb_margin")))
    errset(mtxDump("/home/mseminario2/vestarv/implementations/asic/castalia/analog/data/raw/uf_margin__fs__gmf.csv" getData("gainMarginFreq" ?result "stb_margin")))
    errset(mtxDump("/home/mseminario2/vestarv/implementations/asic/castalia/analog/data/raw/uf_margin__fs__lg0_db.csv" dB20(value(getData("loopGain" ?result "stb") 1.0))))
    errset(mtxDump("/home/mseminario2/vestarv/implementations/asic/castalia/analog/data/raw/uf_margin__fs__lg_ugf.csv" unityGainFreq(getData("loopGain" ?result "stb"))))
    errset(mtxDump("/home/mseminario2/vestarv/implementations/asic/castalia/analog/data/raw/uf_margin__fs__pm.csv" getData("phaseMargin" ?result "stb_margin")))
    errset(mtxDump("/home/mseminario2/vestarv/implementations/asic/castalia/analog/data/raw/uf_margin__fs__pmf.csv" getData("phaseMarginFreq" ?result "stb_margin")))
  )
)

;; ---- corner 133 (fs) / test uf_noise
when(isDir("/home/mseminario2/chips/castalia/simarchive/anatop_tb_controlamp/Interactive.137/133/UnityFeedbackWBiasTB/psf")
  openResults("/home/mseminario2/chips/castalia/simarchive/anatop_tb_controlamp/Interactive.137/133/UnityFeedbackWBiasTB/psf")
  when(member('noise results())
    selectResult('noise)
    mtxP = outfile("/home/mseminario2/vestarv/implementations/asic/castalia/analog/data/raw/uf_noise__fs.meta" "w")
    fprintf(mtxP "sweep %%L\n" car(errset(sweepNames())))
    close(mtxP)
    errset(mtxDump("/home/mseminario2/vestarv/implementations/asic/castalia/analog/data/raw/uf_noise__fs__fcorner.csv" cross(getData("out") sqrt(2)*value(getData("out") 3e5) 1 "either")))
    errset(mtxDump("/home/mseminario2/vestarv/implementations/asic/castalia/analog/data/raw/uf_noise__fs__nfloor.csv" value(getData("out") 3e5)))
    errset(mtxDump("/home/mseminario2/vestarv/implementations/asic/castalia/analog/data/raw/uf_noise__fs__nint_10k.csv" sqrt(integ(getData("out")**2 0.1 1e4))))
    errset(mtxDump("/home/mseminario2/vestarv/implementations/asic/castalia/analog/data/raw/uf_noise__fs__nint_1M.csv" sqrt(integ(getData("out")**2 0.1 1e6))))
    errset(mtxDump("/home/mseminario2/vestarv/implementations/asic/castalia/analog/data/raw/uf_noise__fs__nout.csv" getData("out")))
    errset(mtxDump("/home/mseminario2/vestarv/implementations/asic/castalia/analog/data/raw/uf_noise__fs__nout_1.csv" value(getData("out") 1.0)))
    errset(mtxDump("/home/mseminario2/vestarv/implementations/asic/castalia/analog/data/raw/uf_noise__fs__nout_1k.csv" value(getData("out") 1e3)))
  )
)

;; ---- corner 133 (fs) / test uf_op
when(isDir("/home/mseminario2/chips/castalia/simarchive/anatop_tb_controlamp/Interactive.137/133/UnityFeedbackWBiasTB/psf")
  openResults("/home/mseminario2/chips/castalia/simarchive/anatop_tb_controlamp/Interactive.137/133/UnityFeedbackWBiasTB/psf")
  when(member('dcOp results())
    selectResult('dcOp)
    mtxP = outfile("/home/mseminario2/vestarv/implementations/asic/castalia/analog/data/raw/uf_op__fs.meta" "w")
    fprintf(mtxP "sweep %%L\n" car(errset(sweepNames())))
    close(mtxP)
    errset(mtxDump("/home/mseminario2/vestarv/implementations/asic/castalia/analog/data/raw/uf_op__fs__iamp.csv" abs(i("/OPAMP/vdd!"))))
    errset(mtxDump("/home/mseminario2/vestarv/implementations/asic/castalia/analog/data/raw/uf_op__fs__itot.csv" abs(i("/POWER/SRC_VDD25/PLUS"))))
    errset(mtxDump("/home/mseminario2/vestarv/implementations/asic/castalia/analog/data/raw/uf_op__fs__vbnc.csv" v("/V_BNC")))
    errset(mtxDump("/home/mseminario2/vestarv/implementations/asic/castalia/analog/data/raw/uf_op__fs__vbnm.csv" v("/V_BNM")))
    errset(mtxDump("/home/mseminario2/vestarv/implementations/asic/castalia/analog/data/raw/uf_op__fs__vbpc.csv" v("/V_BPC")))
    errset(mtxDump("/home/mseminario2/vestarv/implementations/asic/castalia/analog/data/raw/uf_op__fs__vbpm.csv" v("/V_BPM")))
    errset(mtxDump("/home/mseminario2/vestarv/implementations/asic/castalia/analog/data/raw/uf_op__fs__vout_op.csv" v("/V_OutOL")))
  )
)

;; ---- corner 134 (sf) / test slew
when(isDir("/home/mseminario2/chips/castalia/simarchive/anatop_tb_controlamp/Interactive.137/134/SlewOpenLoopWBiasTB/psf")
  openResults("/home/mseminario2/chips/castalia/simarchive/anatop_tb_controlamp/Interactive.137/134/SlewOpenLoopWBiasTB/psf")
  when(member('tran results())
    selectResult('tran)
    mtxP = outfile("/home/mseminario2/vestarv/implementations/asic/castalia/analog/data/raw/slew__sf.meta" "w")
    fprintf(mtxP "sweep %%L\n" car(errset(sweepNames())))
    close(mtxP)
    errset(mtxDump("/home/mseminario2/vestarv/implementations/asic/castalia/analog/data/raw/slew__sf__iload.csv" i("/C_L/PLUS")))
    errset(mtxDump("/home/mseminario2/vestarv/implementations/asic/castalia/analog/data/raw/slew__sf__ipk_snk.csv" abs(ymin(i("/C_L/PLUS")))))
    errset(mtxDump("/home/mseminario2/vestarv/implementations/asic/castalia/analog/data/raw/slew__sf__ipk_src.csv" ymax(i("/C_L/PLUS"))))
    errset(mtxDump("/home/mseminario2/vestarv/implementations/asic/castalia/analog/data/raw/slew__sf__isnk.csv" abs(average(clip(i("/C_L/PLUS") cross(v("/V_OutOL") 2.25 1 "falling") cross(v("/V_OutOL") 1.25 1 "falling"))))))
    errset(mtxDump("/home/mseminario2/vestarv/implementations/asic/castalia/analog/data/raw/slew__sf__isrc.csv" average(clip(i("/C_L/PLUS") cross(v("/V_OutOL") 1.25 1 "rising") cross(v("/V_OutOL") 2.25 1 "rising")))))
    errset(mtxDump("/home/mseminario2/vestarv/implementations/asic/castalia/analog/data/raw/slew__sf__sr_dn.csv" 1.0/(cross(v("/V_OutOL") 1.25 1 "falling")-cross(v("/V_OutOL") 2.25 1 "falling"))))
    errset(mtxDump("/home/mseminario2/vestarv/implementations/asic/castalia/analog/data/raw/slew__sf__sr_up.csv" 1.0/(cross(v("/V_OutOL") 2.25 1 "rising")-cross(v("/V_OutOL") 1.25 1 "rising"))))
    errset(mtxDump("/home/mseminario2/vestarv/implementations/asic/castalia/analog/data/raw/slew__sf__vin.csv" v("/V_InP")))
    errset(mtxDump("/home/mseminario2/vestarv/implementations/asic/castalia/analog/data/raw/slew__sf__vout.csv" v("/V_OutOL")))
  )
)

;; ---- corner 134 (sf) / test uf_dc
when(isDir("/home/mseminario2/chips/castalia/simarchive/anatop_tb_controlamp/Interactive.137/134/UnityFeedbackWBiasTB/psf")
  openResults("/home/mseminario2/chips/castalia/simarchive/anatop_tb_controlamp/Interactive.137/134/UnityFeedbackWBiasTB/psf")
  when(member('dc results())
    selectResult('dc)
    mtxP = outfile("/home/mseminario2/vestarv/implementations/asic/castalia/analog/data/raw/uf_dc__sf.meta" "w")
    fprintf(mtxP "sweep %%L\n" car(errset(sweepNames())))
    close(mtxP)
    errset(mtxDump("/home/mseminario2/vestarv/implementations/asic/castalia/analog/data/raw/uf_dc__sf__idd.csv" abs(i("/POWER/SRC_VDD25/PLUS"))))
    errset(mtxDump("/home/mseminario2/vestarv/implementations/asic/castalia/analog/data/raw/uf_dc__sf__verr.csv" (v("/V_OutOL")-v("/V_InP"))))
    errset(mtxDump("/home/mseminario2/vestarv/implementations/asic/castalia/analog/data/raw/uf_dc__sf__vin_hi.csv" cross(abs(v("/V_OutOL")-v("/V_InP")) 1e-3 1 "rising")))
    errset(mtxDump("/home/mseminario2/vestarv/implementations/asic/castalia/analog/data/raw/uf_dc__sf__vin_lo.csv" cross(abs(v("/V_OutOL")-v("/V_InP")) 1e-3 1 "falling")))
    errset(mtxDump("/home/mseminario2/vestarv/implementations/asic/castalia/analog/data/raw/uf_dc__sf__vos.csv" value(v("/V_OutOL")-v("/V_InP") 1.25)))
    errset(mtxDump("/home/mseminario2/vestarv/implementations/asic/castalia/analog/data/raw/uf_dc__sf__vout.csv" v("/V_OutOL")))
  )
)

;; ---- corner 134 (sf) / test uf_margin
when(isDir("/home/mseminario2/chips/castalia/simarchive/anatop_tb_controlamp/Interactive.137/134/UnityFeedbackWBiasTB/psf")
  openResults("/home/mseminario2/chips/castalia/simarchive/anatop_tb_controlamp/Interactive.137/134/UnityFeedbackWBiasTB/psf")
  when(member('stb_margin results())
    selectResult('stb_margin)
    mtxP = outfile("/home/mseminario2/vestarv/implementations/asic/castalia/analog/data/raw/uf_margin__sf.meta" "w")
    fprintf(mtxP "sweep %%L\n" car(errset(sweepNames())))
    close(mtxP)
    errset(mtxDump("/home/mseminario2/vestarv/implementations/asic/castalia/analog/data/raw/uf_margin__sf__gm.csv" getData("gainMargin" ?result "stb_margin")))
    errset(mtxDump("/home/mseminario2/vestarv/implementations/asic/castalia/analog/data/raw/uf_margin__sf__gmf.csv" getData("gainMarginFreq" ?result "stb_margin")))
    errset(mtxDump("/home/mseminario2/vestarv/implementations/asic/castalia/analog/data/raw/uf_margin__sf__lg0_db.csv" dB20(value(getData("loopGain" ?result "stb") 1.0))))
    errset(mtxDump("/home/mseminario2/vestarv/implementations/asic/castalia/analog/data/raw/uf_margin__sf__lg_ugf.csv" unityGainFreq(getData("loopGain" ?result "stb"))))
    errset(mtxDump("/home/mseminario2/vestarv/implementations/asic/castalia/analog/data/raw/uf_margin__sf__pm.csv" getData("phaseMargin" ?result "stb_margin")))
    errset(mtxDump("/home/mseminario2/vestarv/implementations/asic/castalia/analog/data/raw/uf_margin__sf__pmf.csv" getData("phaseMarginFreq" ?result "stb_margin")))
  )
)

;; ---- corner 134 (sf) / test uf_noise
when(isDir("/home/mseminario2/chips/castalia/simarchive/anatop_tb_controlamp/Interactive.137/134/UnityFeedbackWBiasTB/psf")
  openResults("/home/mseminario2/chips/castalia/simarchive/anatop_tb_controlamp/Interactive.137/134/UnityFeedbackWBiasTB/psf")
  when(member('noise results())
    selectResult('noise)
    mtxP = outfile("/home/mseminario2/vestarv/implementations/asic/castalia/analog/data/raw/uf_noise__sf.meta" "w")
    fprintf(mtxP "sweep %%L\n" car(errset(sweepNames())))
    close(mtxP)
    errset(mtxDump("/home/mseminario2/vestarv/implementations/asic/castalia/analog/data/raw/uf_noise__sf__fcorner.csv" cross(getData("out") sqrt(2)*value(getData("out") 3e5) 1 "either")))
    errset(mtxDump("/home/mseminario2/vestarv/implementations/asic/castalia/analog/data/raw/uf_noise__sf__nfloor.csv" value(getData("out") 3e5)))
    errset(mtxDump("/home/mseminario2/vestarv/implementations/asic/castalia/analog/data/raw/uf_noise__sf__nint_10k.csv" sqrt(integ(getData("out")**2 0.1 1e4))))
    errset(mtxDump("/home/mseminario2/vestarv/implementations/asic/castalia/analog/data/raw/uf_noise__sf__nint_1M.csv" sqrt(integ(getData("out")**2 0.1 1e6))))
    errset(mtxDump("/home/mseminario2/vestarv/implementations/asic/castalia/analog/data/raw/uf_noise__sf__nout.csv" getData("out")))
    errset(mtxDump("/home/mseminario2/vestarv/implementations/asic/castalia/analog/data/raw/uf_noise__sf__nout_1.csv" value(getData("out") 1.0)))
    errset(mtxDump("/home/mseminario2/vestarv/implementations/asic/castalia/analog/data/raw/uf_noise__sf__nout_1k.csv" value(getData("out") 1e3)))
  )
)

;; ---- corner 134 (sf) / test uf_op
when(isDir("/home/mseminario2/chips/castalia/simarchive/anatop_tb_controlamp/Interactive.137/134/UnityFeedbackWBiasTB/psf")
  openResults("/home/mseminario2/chips/castalia/simarchive/anatop_tb_controlamp/Interactive.137/134/UnityFeedbackWBiasTB/psf")
  when(member('dcOp results())
    selectResult('dcOp)
    mtxP = outfile("/home/mseminario2/vestarv/implementations/asic/castalia/analog/data/raw/uf_op__sf.meta" "w")
    fprintf(mtxP "sweep %%L\n" car(errset(sweepNames())))
    close(mtxP)
    errset(mtxDump("/home/mseminario2/vestarv/implementations/asic/castalia/analog/data/raw/uf_op__sf__iamp.csv" abs(i("/OPAMP/vdd!"))))
    errset(mtxDump("/home/mseminario2/vestarv/implementations/asic/castalia/analog/data/raw/uf_op__sf__itot.csv" abs(i("/POWER/SRC_VDD25/PLUS"))))
    errset(mtxDump("/home/mseminario2/vestarv/implementations/asic/castalia/analog/data/raw/uf_op__sf__vbnc.csv" v("/V_BNC")))
    errset(mtxDump("/home/mseminario2/vestarv/implementations/asic/castalia/analog/data/raw/uf_op__sf__vbnm.csv" v("/V_BNM")))
    errset(mtxDump("/home/mseminario2/vestarv/implementations/asic/castalia/analog/data/raw/uf_op__sf__vbpc.csv" v("/V_BPC")))
    errset(mtxDump("/home/mseminario2/vestarv/implementations/asic/castalia/analog/data/raw/uf_op__sf__vbpm.csv" v("/V_BPM")))
    errset(mtxDump("/home/mseminario2/vestarv/implementations/asic/castalia/analog/data/raw/uf_op__sf__vout_op.csv" v("/V_OutOL")))
  )
)

;; ---- corner 135 (ss) / test slew
when(isDir("/home/mseminario2/chips/castalia/simarchive/anatop_tb_controlamp/Interactive.137/135/SlewOpenLoopWBiasTB/psf")
  openResults("/home/mseminario2/chips/castalia/simarchive/anatop_tb_controlamp/Interactive.137/135/SlewOpenLoopWBiasTB/psf")
  when(member('tran results())
    selectResult('tran)
    mtxP = outfile("/home/mseminario2/vestarv/implementations/asic/castalia/analog/data/raw/slew__ss.meta" "w")
    fprintf(mtxP "sweep %%L\n" car(errset(sweepNames())))
    close(mtxP)
    errset(mtxDump("/home/mseminario2/vestarv/implementations/asic/castalia/analog/data/raw/slew__ss__iload.csv" i("/C_L/PLUS")))
    errset(mtxDump("/home/mseminario2/vestarv/implementations/asic/castalia/analog/data/raw/slew__ss__ipk_snk.csv" abs(ymin(i("/C_L/PLUS")))))
    errset(mtxDump("/home/mseminario2/vestarv/implementations/asic/castalia/analog/data/raw/slew__ss__ipk_src.csv" ymax(i("/C_L/PLUS"))))
    errset(mtxDump("/home/mseminario2/vestarv/implementations/asic/castalia/analog/data/raw/slew__ss__isnk.csv" abs(average(clip(i("/C_L/PLUS") cross(v("/V_OutOL") 2.25 1 "falling") cross(v("/V_OutOL") 1.25 1 "falling"))))))
    errset(mtxDump("/home/mseminario2/vestarv/implementations/asic/castalia/analog/data/raw/slew__ss__isrc.csv" average(clip(i("/C_L/PLUS") cross(v("/V_OutOL") 1.25 1 "rising") cross(v("/V_OutOL") 2.25 1 "rising")))))
    errset(mtxDump("/home/mseminario2/vestarv/implementations/asic/castalia/analog/data/raw/slew__ss__sr_dn.csv" 1.0/(cross(v("/V_OutOL") 1.25 1 "falling")-cross(v("/V_OutOL") 2.25 1 "falling"))))
    errset(mtxDump("/home/mseminario2/vestarv/implementations/asic/castalia/analog/data/raw/slew__ss__sr_up.csv" 1.0/(cross(v("/V_OutOL") 2.25 1 "rising")-cross(v("/V_OutOL") 1.25 1 "rising"))))
    errset(mtxDump("/home/mseminario2/vestarv/implementations/asic/castalia/analog/data/raw/slew__ss__vin.csv" v("/V_InP")))
    errset(mtxDump("/home/mseminario2/vestarv/implementations/asic/castalia/analog/data/raw/slew__ss__vout.csv" v("/V_OutOL")))
  )
)

;; ---- corner 135 (ss) / test uf_dc
when(isDir("/home/mseminario2/chips/castalia/simarchive/anatop_tb_controlamp/Interactive.137/135/UnityFeedbackWBiasTB/psf")
  openResults("/home/mseminario2/chips/castalia/simarchive/anatop_tb_controlamp/Interactive.137/135/UnityFeedbackWBiasTB/psf")
  when(member('dc results())
    selectResult('dc)
    mtxP = outfile("/home/mseminario2/vestarv/implementations/asic/castalia/analog/data/raw/uf_dc__ss.meta" "w")
    fprintf(mtxP "sweep %%L\n" car(errset(sweepNames())))
    close(mtxP)
    errset(mtxDump("/home/mseminario2/vestarv/implementations/asic/castalia/analog/data/raw/uf_dc__ss__idd.csv" abs(i("/POWER/SRC_VDD25/PLUS"))))
    errset(mtxDump("/home/mseminario2/vestarv/implementations/asic/castalia/analog/data/raw/uf_dc__ss__verr.csv" (v("/V_OutOL")-v("/V_InP"))))
    errset(mtxDump("/home/mseminario2/vestarv/implementations/asic/castalia/analog/data/raw/uf_dc__ss__vin_hi.csv" cross(abs(v("/V_OutOL")-v("/V_InP")) 1e-3 1 "rising")))
    errset(mtxDump("/home/mseminario2/vestarv/implementations/asic/castalia/analog/data/raw/uf_dc__ss__vin_lo.csv" cross(abs(v("/V_OutOL")-v("/V_InP")) 1e-3 1 "falling")))
    errset(mtxDump("/home/mseminario2/vestarv/implementations/asic/castalia/analog/data/raw/uf_dc__ss__vos.csv" value(v("/V_OutOL")-v("/V_InP") 1.25)))
    errset(mtxDump("/home/mseminario2/vestarv/implementations/asic/castalia/analog/data/raw/uf_dc__ss__vout.csv" v("/V_OutOL")))
  )
)

;; ---- corner 135 (ss) / test uf_margin
when(isDir("/home/mseminario2/chips/castalia/simarchive/anatop_tb_controlamp/Interactive.137/135/UnityFeedbackWBiasTB/psf")
  openResults("/home/mseminario2/chips/castalia/simarchive/anatop_tb_controlamp/Interactive.137/135/UnityFeedbackWBiasTB/psf")
  when(member('stb_margin results())
    selectResult('stb_margin)
    mtxP = outfile("/home/mseminario2/vestarv/implementations/asic/castalia/analog/data/raw/uf_margin__ss.meta" "w")
    fprintf(mtxP "sweep %%L\n" car(errset(sweepNames())))
    close(mtxP)
    errset(mtxDump("/home/mseminario2/vestarv/implementations/asic/castalia/analog/data/raw/uf_margin__ss__gm.csv" getData("gainMargin" ?result "stb_margin")))
    errset(mtxDump("/home/mseminario2/vestarv/implementations/asic/castalia/analog/data/raw/uf_margin__ss__gmf.csv" getData("gainMarginFreq" ?result "stb_margin")))
    errset(mtxDump("/home/mseminario2/vestarv/implementations/asic/castalia/analog/data/raw/uf_margin__ss__lg0_db.csv" dB20(value(getData("loopGain" ?result "stb") 1.0))))
    errset(mtxDump("/home/mseminario2/vestarv/implementations/asic/castalia/analog/data/raw/uf_margin__ss__lg_ugf.csv" unityGainFreq(getData("loopGain" ?result "stb"))))
    errset(mtxDump("/home/mseminario2/vestarv/implementations/asic/castalia/analog/data/raw/uf_margin__ss__pm.csv" getData("phaseMargin" ?result "stb_margin")))
    errset(mtxDump("/home/mseminario2/vestarv/implementations/asic/castalia/analog/data/raw/uf_margin__ss__pmf.csv" getData("phaseMarginFreq" ?result "stb_margin")))
  )
)

;; ---- corner 135 (ss) / test uf_noise
when(isDir("/home/mseminario2/chips/castalia/simarchive/anatop_tb_controlamp/Interactive.137/135/UnityFeedbackWBiasTB/psf")
  openResults("/home/mseminario2/chips/castalia/simarchive/anatop_tb_controlamp/Interactive.137/135/UnityFeedbackWBiasTB/psf")
  when(member('noise results())
    selectResult('noise)
    mtxP = outfile("/home/mseminario2/vestarv/implementations/asic/castalia/analog/data/raw/uf_noise__ss.meta" "w")
    fprintf(mtxP "sweep %%L\n" car(errset(sweepNames())))
    close(mtxP)
    errset(mtxDump("/home/mseminario2/vestarv/implementations/asic/castalia/analog/data/raw/uf_noise__ss__fcorner.csv" cross(getData("out") sqrt(2)*value(getData("out") 3e5) 1 "either")))
    errset(mtxDump("/home/mseminario2/vestarv/implementations/asic/castalia/analog/data/raw/uf_noise__ss__nfloor.csv" value(getData("out") 3e5)))
    errset(mtxDump("/home/mseminario2/vestarv/implementations/asic/castalia/analog/data/raw/uf_noise__ss__nint_10k.csv" sqrt(integ(getData("out")**2 0.1 1e4))))
    errset(mtxDump("/home/mseminario2/vestarv/implementations/asic/castalia/analog/data/raw/uf_noise__ss__nint_1M.csv" sqrt(integ(getData("out")**2 0.1 1e6))))
    errset(mtxDump("/home/mseminario2/vestarv/implementations/asic/castalia/analog/data/raw/uf_noise__ss__nout.csv" getData("out")))
    errset(mtxDump("/home/mseminario2/vestarv/implementations/asic/castalia/analog/data/raw/uf_noise__ss__nout_1.csv" value(getData("out") 1.0)))
    errset(mtxDump("/home/mseminario2/vestarv/implementations/asic/castalia/analog/data/raw/uf_noise__ss__nout_1k.csv" value(getData("out") 1e3)))
  )
)

;; ---- corner 135 (ss) / test uf_op
when(isDir("/home/mseminario2/chips/castalia/simarchive/anatop_tb_controlamp/Interactive.137/135/UnityFeedbackWBiasTB/psf")
  openResults("/home/mseminario2/chips/castalia/simarchive/anatop_tb_controlamp/Interactive.137/135/UnityFeedbackWBiasTB/psf")
  when(member('dcOp results())
    selectResult('dcOp)
    mtxP = outfile("/home/mseminario2/vestarv/implementations/asic/castalia/analog/data/raw/uf_op__ss.meta" "w")
    fprintf(mtxP "sweep %%L\n" car(errset(sweepNames())))
    close(mtxP)
    errset(mtxDump("/home/mseminario2/vestarv/implementations/asic/castalia/analog/data/raw/uf_op__ss__iamp.csv" abs(i("/OPAMP/vdd!"))))
    errset(mtxDump("/home/mseminario2/vestarv/implementations/asic/castalia/analog/data/raw/uf_op__ss__itot.csv" abs(i("/POWER/SRC_VDD25/PLUS"))))
    errset(mtxDump("/home/mseminario2/vestarv/implementations/asic/castalia/analog/data/raw/uf_op__ss__vbnc.csv" v("/V_BNC")))
    errset(mtxDump("/home/mseminario2/vestarv/implementations/asic/castalia/analog/data/raw/uf_op__ss__vbnm.csv" v("/V_BNM")))
    errset(mtxDump("/home/mseminario2/vestarv/implementations/asic/castalia/analog/data/raw/uf_op__ss__vbpc.csv" v("/V_BPC")))
    errset(mtxDump("/home/mseminario2/vestarv/implementations/asic/castalia/analog/data/raw/uf_op__ss__vbpm.csv" v("/V_BPM")))
    errset(mtxDump("/home/mseminario2/vestarv/implementations/asic/castalia/analog/data/raw/uf_op__ss__vout_op.csv" v("/V_OutOL")))
  )
)

printf("MTX_EXTRACT_DONE\n")
exit(0)
