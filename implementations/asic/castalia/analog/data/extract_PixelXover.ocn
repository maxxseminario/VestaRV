;; generated by maestro2tex -- do not edit
procedure(mtxDump(fname wv)
  let((xs ys n p)
    p = outfile(fname "w")
    cond(
      (null(wv) fprintf(p "#nil\n"))
      (drIsWaveform(wv)
        xs = drGetWaveformXVec(wv)
        ys = drGetWaveformYVec(wv)
        n = drVectorLength(xs)
        for(i 0 n-1
          fprintf(p "%.10g %.10g\n" drGetElem(xs i) drGetElem(ys i)))
      )
      (t fprintf(p "#scalar %.10g\n" float(wv)))
    )
    close(p)
    t))

;; ---- corner 1 (tt) / test px_xover_dc
when(isDir("/home/mseminario2/chips/castalia/simruns/tb_anatop_pixel_iacc2/castalia/tb_anatop_pixel/maestro/results/maestro/Ocean.0/1/ps_iacc/psf")
  openResults("/home/mseminario2/chips/castalia/simruns/tb_anatop_pixel_iacc2/castalia/tb_anatop_pixel/maestro/results/maestro/Ocean.0/1/ps_iacc/psf")
  when(member('dc results())
    selectResult('dc)
    mtxP = outfile("/home/mseminario2/vestarv/implementations/asic/castalia/analog/data/raw/px_xover_dc__tt.meta" "w")
    fprintf(mtxP "sweep %%L\n" car(errset(sweepNames())))
    close(mtxP)
    errset(mtxDump("/home/mseminario2/vestarv/implementations/asic/castalia/analog/data/raw/px_xover_dc__tt__ierr_lsb.csv" ((((VS("/V_OUT") - VAR("V_CM")) / VAR("rf")) - xval(((VS("/V_OUT") - VAR("V_CM")) / VAR("rf")))) * VAR("rf") / 0.002441)))
  )
)

printf("MTX_EXTRACT_DONE\n")
exit(0)
