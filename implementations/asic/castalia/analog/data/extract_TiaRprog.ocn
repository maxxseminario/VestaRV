;; generated by maestro2tex -- do not edit
procedure(mtxDump(fname wv)
  let((xs ys n p)
    p = outfile(fname "w")
    cond(
      (null(wv) fprintf(p "#nil\n"))
      (drIsWaveform(wv)
        xs = drGetWaveformXVec(wv)
        ys = drGetWaveformYVec(wv)
        n = drVectorLength(xs)
        for(i 0 n-1
          fprintf(p "%.10g %.10g\n" drGetElem(xs i) drGetElem(ys i)))
      )
      (t fprintf(p "#scalar %.10g\n" float(wv)))
    )
    close(p)
    t))

;; ---- corner 1 (typ) / test rp_code
when(isDir("/home/mseminario2/chips/castalia/simruns/tb_anatop_tia_rprog_code/castalia/tb_anatop_tia_rprog/maestro/results/maestro/Ocean.0/1/rp_code/psf")
  openResults("/home/mseminario2/chips/castalia/simruns/tb_anatop_tia_rprog_code/castalia/tb_anatop_tia_rprog/maestro/results/maestro/Ocean.0/1/rp_code/psf")
  when(member('dc results())
    selectResult('dc)
    mtxP = outfile("/home/mseminario2/vestarv/implementations/asic/castalia/analog/data/raw/rp_code__typ.meta" "w")
    fprintf(mtxP "sweep %%L\n" car(errset(sweepNames())))
    close(mtxP)
    errset(mtxDump("/home/mseminario2/vestarv/implementations/asic/castalia/analog/data/raw/rp_code__typ__r_err_pct.csv" (100.0 * (((VS("/A_T") - VS("/B_T")) / 500e-9) - (18000.0 + 6000.0 * xval(VS("/A_T")))) / (18000.0 + 6000.0 * xval(VS("/A_T"))))))
    errset(mtxDump("/home/mseminario2/vestarv/implementations/asic/castalia/analog/data/raw/rp_code__typ__r_kohm.csv" ((VS("/A_T") - VS("/B_T")) / 500e-9)))
    errset(mtxDump("/home/mseminario2/vestarv/implementations/asic/castalia/analog/data/raw/rp_code__typ__r_n0.csv" (value(((VS("/A_T") - VS("/B_T")) / 500e-9) 0) / 1000.0)))
    errset(mtxDump("/home/mseminario2/vestarv/implementations/asic/castalia/analog/data/raw/rp_code__typ__r_n319.csv" (value(((VS("/A_T") - VS("/B_T")) / 500e-9) 319) / 1000000.0)))
    errset(mtxDump("/home/mseminario2/vestarv/implementations/asic/castalia/analog/data/raw/rp_code__typ__r_n63.csv" (value(((VS("/A_T") - VS("/B_T")) / 500e-9) 63) / 1000.0)))
    errset(mtxDump("/home/mseminario2/vestarv/implementations/asic/castalia/analog/data/raw/rp_code__typ__r_n64.csv" (value(((VS("/A_T") - VS("/B_T")) / 500e-9) 64) / 1000.0)))
    errset(mtxDump("/home/mseminario2/vestarv/implementations/asic/castalia/analog/data/raw/rp_code__typ__seam_63_64.csv" ((value(((VS("/A_T") - VS("/B_T")) / 500e-9) 64) - value(((VS("/A_T") - VS("/B_T")) / 500e-9) 63)) / 1000.0)))
    errset(mtxDump("/home/mseminario2/vestarv/implementations/asic/castalia/analog/data/raw/rp_code__typ__step_max.csv" ymax(deriv(((VS("/A_T") - VS("/B_T")) / 500e-9)))))
    errset(mtxDump("/home/mseminario2/vestarv/implementations/asic/castalia/analog/data/raw/rp_code__typ__step_mean.csv" ((value(((VS("/A_T") - VS("/B_T")) / 500e-9) 319) - value(((VS("/A_T") - VS("/B_T")) / 500e-9) 0)) / 319.0)))
    errset(mtxDump("/home/mseminario2/vestarv/implementations/asic/castalia/analog/data/raw/rp_code__typ__step_min.csv" ymin(deriv(((VS("/A_T") - VS("/B_T")) / 500e-9)))))
  )
)

;; ---- corner 2 (ff-res) / test rp_code
when(isDir("/home/mseminario2/chips/castalia/simruns/tb_anatop_tia_rprog_code/castalia/tb_anatop_tia_rprog/maestro/results/maestro/Ocean.0/2/rp_code/psf")
  openResults("/home/mseminario2/chips/castalia/simruns/tb_anatop_tia_rprog_code/castalia/tb_anatop_tia_rprog/maestro/results/maestro/Ocean.0/2/rp_code/psf")
  when(member('dc results())
    selectResult('dc)
    mtxP = outfile("/home/mseminario2/vestarv/implementations/asic/castalia/analog/data/raw/rp_code__ff-res.meta" "w")
    fprintf(mtxP "sweep %%L\n" car(errset(sweepNames())))
    close(mtxP)
    errset(mtxDump("/home/mseminario2/vestarv/implementations/asic/castalia/analog/data/raw/rp_code__ff-res__r_err_pct.csv" (100.0 * (((VS("/A_T") - VS("/B_T")) / 500e-9) - (18000.0 + 6000.0 * xval(VS("/A_T")))) / (18000.0 + 6000.0 * xval(VS("/A_T"))))))
    errset(mtxDump("/home/mseminario2/vestarv/implementations/asic/castalia/analog/data/raw/rp_code__ff-res__r_kohm.csv" ((VS("/A_T") - VS("/B_T")) / 500e-9)))
    errset(mtxDump("/home/mseminario2/vestarv/implementations/asic/castalia/analog/data/raw/rp_code__ff-res__r_n0.csv" (value(((VS("/A_T") - VS("/B_T")) / 500e-9) 0) / 1000.0)))
    errset(mtxDump("/home/mseminario2/vestarv/implementations/asic/castalia/analog/data/raw/rp_code__ff-res__r_n319.csv" (value(((VS("/A_T") - VS("/B_T")) / 500e-9) 319) / 1000000.0)))
    errset(mtxDump("/home/mseminario2/vestarv/implementations/asic/castalia/analog/data/raw/rp_code__ff-res__r_n63.csv" (value(((VS("/A_T") - VS("/B_T")) / 500e-9) 63) / 1000.0)))
    errset(mtxDump("/home/mseminario2/vestarv/implementations/asic/castalia/analog/data/raw/rp_code__ff-res__r_n64.csv" (value(((VS("/A_T") - VS("/B_T")) / 500e-9) 64) / 1000.0)))
    errset(mtxDump("/home/mseminario2/vestarv/implementations/asic/castalia/analog/data/raw/rp_code__ff-res__seam_63_64.csv" ((value(((VS("/A_T") - VS("/B_T")) / 500e-9) 64) - value(((VS("/A_T") - VS("/B_T")) / 500e-9) 63)) / 1000.0)))
    errset(mtxDump("/home/mseminario2/vestarv/implementations/asic/castalia/analog/data/raw/rp_code__ff-res__step_max.csv" ymax(deriv(((VS("/A_T") - VS("/B_T")) / 500e-9)))))
    errset(mtxDump("/home/mseminario2/vestarv/implementations/asic/castalia/analog/data/raw/rp_code__ff-res__step_mean.csv" ((value(((VS("/A_T") - VS("/B_T")) / 500e-9) 319) - value(((VS("/A_T") - VS("/B_T")) / 500e-9) 0)) / 319.0)))
    errset(mtxDump("/home/mseminario2/vestarv/implementations/asic/castalia/analog/data/raw/rp_code__ff-res__step_min.csv" ymin(deriv(((VS("/A_T") - VS("/B_T")) / 500e-9)))))
  )
)

;; ---- corner 3 (ss-res) / test rp_code
when(isDir("/home/mseminario2/chips/castalia/simruns/tb_anatop_tia_rprog_code/castalia/tb_anatop_tia_rprog/maestro/results/maestro/Ocean.0/3/rp_code/psf")
  openResults("/home/mseminario2/chips/castalia/simruns/tb_anatop_tia_rprog_code/castalia/tb_anatop_tia_rprog/maestro/results/maestro/Ocean.0/3/rp_code/psf")
  when(member('dc results())
    selectResult('dc)
    mtxP = outfile("/home/mseminario2/vestarv/implementations/asic/castalia/analog/data/raw/rp_code__ss-res.meta" "w")
    fprintf(mtxP "sweep %%L\n" car(errset(sweepNames())))
    close(mtxP)
    errset(mtxDump("/home/mseminario2/vestarv/implementations/asic/castalia/analog/data/raw/rp_code__ss-res__r_err_pct.csv" (100.0 * (((VS("/A_T") - VS("/B_T")) / 500e-9) - (18000.0 + 6000.0 * xval(VS("/A_T")))) / (18000.0 + 6000.0 * xval(VS("/A_T"))))))
    errset(mtxDump("/home/mseminario2/vestarv/implementations/asic/castalia/analog/data/raw/rp_code__ss-res__r_kohm.csv" ((VS("/A_T") - VS("/B_T")) / 500e-9)))
    errset(mtxDump("/home/mseminario2/vestarv/implementations/asic/castalia/analog/data/raw/rp_code__ss-res__r_n0.csv" (value(((VS("/A_T") - VS("/B_T")) / 500e-9) 0) / 1000.0)))
    errset(mtxDump("/home/mseminario2/vestarv/implementations/asic/castalia/analog/data/raw/rp_code__ss-res__r_n319.csv" (value(((VS("/A_T") - VS("/B_T")) / 500e-9) 319) / 1000000.0)))
    errset(mtxDump("/home/mseminario2/vestarv/implementations/asic/castalia/analog/data/raw/rp_code__ss-res__r_n63.csv" (value(((VS("/A_T") - VS("/B_T")) / 500e-9) 63) / 1000.0)))
    errset(mtxDump("/home/mseminario2/vestarv/implementations/asic/castalia/analog/data/raw/rp_code__ss-res__r_n64.csv" (value(((VS("/A_T") - VS("/B_T")) / 500e-9) 64) / 1000.0)))
    errset(mtxDump("/home/mseminario2/vestarv/implementations/asic/castalia/analog/data/raw/rp_code__ss-res__seam_63_64.csv" ((value(((VS("/A_T") - VS("/B_T")) / 500e-9) 64) - value(((VS("/A_T") - VS("/B_T")) / 500e-9) 63)) / 1000.0)))
    errset(mtxDump("/home/mseminario2/vestarv/implementations/asic/castalia/analog/data/raw/rp_code__ss-res__step_max.csv" ymax(deriv(((VS("/A_T") - VS("/B_T")) / 500e-9)))))
    errset(mtxDump("/home/mseminario2/vestarv/implementations/asic/castalia/analog/data/raw/rp_code__ss-res__step_mean.csv" ((value(((VS("/A_T") - VS("/B_T")) / 500e-9) 319) - value(((VS("/A_T") - VS("/B_T")) / 500e-9) 0)) / 319.0)))
    errset(mtxDump("/home/mseminario2/vestarv/implementations/asic/castalia/analog/data/raw/rp_code__ss-res__step_min.csv" ymin(deriv(((VS("/A_T") - VS("/B_T")) / 500e-9)))))
  )
)

;; ---- corner 4 (ff -40C) / test rp_code
when(isDir("/home/mseminario2/chips/castalia/simruns/tb_anatop_tia_rprog_code/castalia/tb_anatop_tia_rprog/maestro/results/maestro/Ocean.0/4/rp_code/psf")
  openResults("/home/mseminario2/chips/castalia/simruns/tb_anatop_tia_rprog_code/castalia/tb_anatop_tia_rprog/maestro/results/maestro/Ocean.0/4/rp_code/psf")
  when(member('dc results())
    selectResult('dc)
    mtxP = outfile("/home/mseminario2/vestarv/implementations/asic/castalia/analog/data/raw/rp_code__ff -40C.meta" "w")
    fprintf(mtxP "sweep %%L\n" car(errset(sweepNames())))
    close(mtxP)
    errset(mtxDump("/home/mseminario2/vestarv/implementations/asic/castalia/analog/data/raw/rp_code__ff -40C__r_err_pct.csv" (100.0 * (((VS("/A_T") - VS("/B_T")) / 500e-9) - (18000.0 + 6000.0 * xval(VS("/A_T")))) / (18000.0 + 6000.0 * xval(VS("/A_T"))))))
    errset(mtxDump("/home/mseminario2/vestarv/implementations/asic/castalia/analog/data/raw/rp_code__ff -40C__r_kohm.csv" ((VS("/A_T") - VS("/B_T")) / 500e-9)))
    errset(mtxDump("/home/mseminario2/vestarv/implementations/asic/castalia/analog/data/raw/rp_code__ff -40C__r_n0.csv" (value(((VS("/A_T") - VS("/B_T")) / 500e-9) 0) / 1000.0)))
    errset(mtxDump("/home/mseminario2/vestarv/implementations/asic/castalia/analog/data/raw/rp_code__ff -40C__r_n319.csv" (value(((VS("/A_T") - VS("/B_T")) / 500e-9) 319) / 1000000.0)))
    errset(mtxDump("/home/mseminario2/vestarv/implementations/asic/castalia/analog/data/raw/rp_code__ff -40C__r_n63.csv" (value(((VS("/A_T") - VS("/B_T")) / 500e-9) 63) / 1000.0)))
    errset(mtxDump("/home/mseminario2/vestarv/implementations/asic/castalia/analog/data/raw/rp_code__ff -40C__r_n64.csv" (value(((VS("/A_T") - VS("/B_T")) / 500e-9) 64) / 1000.0)))
    errset(mtxDump("/home/mseminario2/vestarv/implementations/asic/castalia/analog/data/raw/rp_code__ff -40C__seam_63_64.csv" ((value(((VS("/A_T") - VS("/B_T")) / 500e-9) 64) - value(((VS("/A_T") - VS("/B_T")) / 500e-9) 63)) / 1000.0)))
    errset(mtxDump("/home/mseminario2/vestarv/implementations/asic/castalia/analog/data/raw/rp_code__ff -40C__step_max.csv" ymax(deriv(((VS("/A_T") - VS("/B_T")) / 500e-9)))))
    errset(mtxDump("/home/mseminario2/vestarv/implementations/asic/castalia/analog/data/raw/rp_code__ff -40C__step_mean.csv" ((value(((VS("/A_T") - VS("/B_T")) / 500e-9) 319) - value(((VS("/A_T") - VS("/B_T")) / 500e-9) 0)) / 319.0)))
    errset(mtxDump("/home/mseminario2/vestarv/implementations/asic/castalia/analog/data/raw/rp_code__ff -40C__step_min.csv" ymin(deriv(((VS("/A_T") - VS("/B_T")) / 500e-9)))))
  )
)

;; ---- corner 5 (ss 125C) / test rp_code
when(isDir("/home/mseminario2/chips/castalia/simruns/tb_anatop_tia_rprog_code/castalia/tb_anatop_tia_rprog/maestro/results/maestro/Ocean.0/5/rp_code/psf")
  openResults("/home/mseminario2/chips/castalia/simruns/tb_anatop_tia_rprog_code/castalia/tb_anatop_tia_rprog/maestro/results/maestro/Ocean.0/5/rp_code/psf")
  when(member('dc results())
    selectResult('dc)
    mtxP = outfile("/home/mseminario2/vestarv/implementations/asic/castalia/analog/data/raw/rp_code__ss 125C.meta" "w")
    fprintf(mtxP "sweep %%L\n" car(errset(sweepNames())))
    close(mtxP)
    errset(mtxDump("/home/mseminario2/vestarv/implementations/asic/castalia/analog/data/raw/rp_code__ss 125C__r_err_pct.csv" (100.0 * (((VS("/A_T") - VS("/B_T")) / 500e-9) - (18000.0 + 6000.0 * xval(VS("/A_T")))) / (18000.0 + 6000.0 * xval(VS("/A_T"))))))
    errset(mtxDump("/home/mseminario2/vestarv/implementations/asic/castalia/analog/data/raw/rp_code__ss 125C__r_kohm.csv" ((VS("/A_T") - VS("/B_T")) / 500e-9)))
    errset(mtxDump("/home/mseminario2/vestarv/implementations/asic/castalia/analog/data/raw/rp_code__ss 125C__r_n0.csv" (value(((VS("/A_T") - VS("/B_T")) / 500e-9) 0) / 1000.0)))
    errset(mtxDump("/home/mseminario2/vestarv/implementations/asic/castalia/analog/data/raw/rp_code__ss 125C__r_n319.csv" (value(((VS("/A_T") - VS("/B_T")) / 500e-9) 319) / 1000000.0)))
    errset(mtxDump("/home/mseminario2/vestarv/implementations/asic/castalia/analog/data/raw/rp_code__ss 125C__r_n63.csv" (value(((VS("/A_T") - VS("/B_T")) / 500e-9) 63) / 1000.0)))
    errset(mtxDump("/home/mseminario2/vestarv/implementations/asic/castalia/analog/data/raw/rp_code__ss 125C__r_n64.csv" (value(((VS("/A_T") - VS("/B_T")) / 500e-9) 64) / 1000.0)))
    errset(mtxDump("/home/mseminario2/vestarv/implementations/asic/castalia/analog/data/raw/rp_code__ss 125C__seam_63_64.csv" ((value(((VS("/A_T") - VS("/B_T")) / 500e-9) 64) - value(((VS("/A_T") - VS("/B_T")) / 500e-9) 63)) / 1000.0)))
    errset(mtxDump("/home/mseminario2/vestarv/implementations/asic/castalia/analog/data/raw/rp_code__ss 125C__step_max.csv" ymax(deriv(((VS("/A_T") - VS("/B_T")) / 500e-9)))))
    errset(mtxDump("/home/mseminario2/vestarv/implementations/asic/castalia/analog/data/raw/rp_code__ss 125C__step_mean.csv" ((value(((VS("/A_T") - VS("/B_T")) / 500e-9) 319) - value(((VS("/A_T") - VS("/B_T")) / 500e-9) 0)) / 319.0)))
    errset(mtxDump("/home/mseminario2/vestarv/implementations/asic/castalia/analog/data/raw/rp_code__ss 125C__step_min.csv" ymin(deriv(((VS("/A_T") - VS("/B_T")) / 500e-9)))))
  )
)

printf("MTX_EXTRACT_DONE\n")
exit(0)
