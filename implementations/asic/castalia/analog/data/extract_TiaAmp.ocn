;; generated by maestro2tex -- do not edit
procedure(mtxDump(fname wv)
  let((xs ys n p)
    p = outfile(fname "w")
    cond(
      (null(wv) fprintf(p "#nil\n"))
      (drIsWaveform(wv)
        xs = drGetWaveformXVec(wv)
        ys = drGetWaveformYVec(wv)
        n = drVectorLength(xs)
        for(i 0 n-1
          fprintf(p "%.10g %.10g\n" drGetElem(xs i) drGetElem(ys i)))
      )
      (t fprintf(p "#scalar %.10g\n" float(wv)))
    )
    close(p)
    t))

;; ---- corner 1 (tt) / test amp_dc
when(isDir("/home/mseminario2/chips/castalia/simarchive/anatop_tb_tia/tia_2026-07-28/Interactive.9/1/UnityFeedbackTB/psf")
  openResults("/home/mseminario2/chips/castalia/simarchive/anatop_tb_tia/tia_2026-07-28/Interactive.9/1/UnityFeedbackTB/psf")
  when(member('dc results())
    selectResult('dc)
    mtxP = outfile("/home/mseminario2/vestarv/implementations/asic/castalia/analog/data/raw/amp_dc__tt.meta" "w")
    fprintf(mtxP "sweep %%L\n" car(errset(sweepNames())))
    close(mtxP)
    errset(mtxDump("/home/mseminario2/vestarv/implementations/asic/castalia/analog/data/raw/amp_dc__tt__cm_hi.csv" cross(abs(VS("/V_OutOL")-VS("/V_InP")) 0.002 1 "rising")))
    errset(mtxDump("/home/mseminario2/vestarv/implementations/asic/castalia/analog/data/raw/amp_dc__tt__cm_lo.csv" cross(abs(VS("/V_OutOL")-VS("/V_InP")) 0.002 1 "falling")))
    errset(mtxDump("/home/mseminario2/vestarv/implementations/asic/castalia/analog/data/raw/amp_dc__tt__track_err.csv" value(abs(VS("/V_OutOL")-VS("/V_InP")) 1.25)))
    errset(mtxDump("/home/mseminario2/vestarv/implementations/asic/castalia/analog/data/raw/amp_dc__tt__vos.csv" value((VS("/V_OutOL") - VS("/V_InP")) 1.25)))
  )
)

;; ---- corner 1 (tt) / test amp_noise
when(isDir("/home/mseminario2/chips/castalia/simarchive/anatop_tb_tia/tia_2026-07-28/Interactive.9/1/UnityFeedbackTB/psf")
  openResults("/home/mseminario2/chips/castalia/simarchive/anatop_tb_tia/tia_2026-07-28/Interactive.9/1/UnityFeedbackTB/psf")
  when(member('noise results())
    selectResult('noise)
    mtxP = outfile("/home/mseminario2/vestarv/implementations/asic/castalia/analog/data/raw/amp_noise__tt.meta" "w")
    fprintf(mtxP "sweep %%L\n" car(errset(sweepNames())))
    close(mtxP)
    errset(mtxDump("/home/mseminario2/vestarv/implementations/asic/castalia/analog/data/raw/amp_noise__tt__vn_10.csv" value(getData("in" ?result "noise") 10.0)))
    errset(mtxDump("/home/mseminario2/vestarv/implementations/asic/castalia/analog/data/raw/amp_noise__tt__vn_100.csv" value(getData("in" ?result "noise") 100.0)))
    errset(mtxDump("/home/mseminario2/vestarv/implementations/asic/castalia/analog/data/raw/amp_noise__tt__vn_1k.csv" value(getData("in" ?result "noise") 1000.0)))
    errset(mtxDump("/home/mseminario2/vestarv/implementations/asic/castalia/analog/data/raw/amp_noise__tt__vn_int.csv" sqrt(integ(getData("in" ?result "noise")**2 0.1 1700.0))))
  )
)

;; ---- corner 1 (tt) / test amp_op
when(isDir("/home/mseminario2/chips/castalia/simarchive/anatop_tb_tia/tia_2026-07-28/Interactive.9/1/UnityFeedbackTB/psf")
  openResults("/home/mseminario2/chips/castalia/simarchive/anatop_tb_tia/tia_2026-07-28/Interactive.9/1/UnityFeedbackTB/psf")
  when(member('dcOpInfo results())
    selectResult('dcOpInfo)
    mtxP = outfile("/home/mseminario2/vestarv/implementations/asic/castalia/analog/data/raw/amp_op__tt.meta" "w")
    fprintf(mtxP "sweep %%L\n" car(errset(sweepNames())))
    close(mtxP)
    errset(mtxDump("/home/mseminario2/vestarv/implementations/asic/castalia/analog/data/raw/amp_op__tt__a0_pred.csv" dB20((OP("/OPAMP/M4" "gm")/(OP("/OPAMP/M4" "gds")+OP("/OPAMP/M11" "gds")))*(OP("/OPAMP/M12" "gm")/(OP("/OPAMP/M12" "gds")+OP("/OPAMP/M5" "gds"))))))
    errset(mtxDump("/home/mseminario2/vestarv/implementations/asic/castalia/analog/data/raw/amp_op__tt__cc.csv" OP("/OPAMP/C0" "cap")))
    errset(mtxDump("/home/mseminario2/vestarv/implementations/asic/castalia/analog/data/raw/amp_op__tt__fp1_pred.csv" 1.0/(2*3.14159265358979*(1.0/(OP("/OPAMP/M4" "gds")+OP("/OPAMP/M11" "gds")))*(OP("/OPAMP/M12" "gm")/(OP("/OPAMP/M12" "gds")+OP("/OPAMP/M5" "gds")))*OP("/OPAMP/C0" "cap"))))
    errset(mtxDump("/home/mseminario2/vestarv/implementations/asic/castalia/analog/data/raw/amp_op__tt__fp2_pred.csv" OP("/OPAMP/M12" "gm")/(2*3.14159265358979*VAR("C_L"))))
    errset(mtxDump("/home/mseminario2/vestarv/implementations/asic/castalia/analog/data/raw/amp_op__tt__fu_pred.csv" OP("/OPAMP/M4" "gm")/(2*3.14159265358979*OP("/OPAMP/C0" "cap"))))
    errset(mtxDump("/home/mseminario2/vestarv/implementations/asic/castalia/analog/data/raw/amp_op__tt__gm1.csv" OP("/OPAMP/M4" "gm")))
    errset(mtxDump("/home/mseminario2/vestarv/implementations/asic/castalia/analog/data/raw/amp_op__tt__gm2.csv" OP("/OPAMP/M12" "gm")))
    errset(mtxDump("/home/mseminario2/vestarv/implementations/asic/castalia/analog/data/raw/amp_op__tt__itail.csv" abs(OP("/OPAMP/M2" "id"))))
    errset(mtxDump("/home/mseminario2/vestarv/implementations/asic/castalia/analog/data/raw/amp_op__tt__r1.csv" 1.0/(OP("/OPAMP/M4" "gds")+OP("/OPAMP/M11" "gds"))))
    errset(mtxDump("/home/mseminario2/vestarv/implementations/asic/castalia/analog/data/raw/amp_op__tt__r2.csv" 1.0/(OP("/OPAMP/M12" "gds")+OP("/OPAMP/M5" "gds"))))
  )
)

;; ---- corner 1 (tt) / test amp_stb
when(isDir("/home/mseminario2/chips/castalia/simarchive/anatop_tb_tia/tia_2026-07-28/Interactive.9/1/UnityFeedbackTB/psf")
  openResults("/home/mseminario2/chips/castalia/simarchive/anatop_tb_tia/tia_2026-07-28/Interactive.9/1/UnityFeedbackTB/psf")
  when(member('stb results())
    selectResult('stb)
    mtxP = outfile("/home/mseminario2/vestarv/implementations/asic/castalia/analog/data/raw/amp_stb__tt.meta" "w")
    fprintf(mtxP "sweep %%L\n" car(errset(sweepNames())))
    close(mtxP)
    errset(mtxDump("/home/mseminario2/vestarv/implementations/asic/castalia/analog/data/raw/amp_stb__tt__a0.csv" ymax(dB20(getData("loopGain" ?result "stb")))))
    errset(mtxDump("/home/mseminario2/vestarv/implementations/asic/castalia/analog/data/raw/amp_stb__tt__fp1_meas.csv" bandwidth(getData("loopGain" ?result "stb") 3 "low")))
    errset(mtxDump("/home/mseminario2/vestarv/implementations/asic/castalia/analog/data/raw/amp_stb__tt__gm.csv" getData("gainMargin" ?result "stb_margin")))
    errset(mtxDump("/home/mseminario2/vestarv/implementations/asic/castalia/analog/data/raw/amp_stb__tt__lg_db.csv" dB20(getData("loopGain" ?result "stb"))))
    errset(mtxDump("/home/mseminario2/vestarv/implementations/asic/castalia/analog/data/raw/amp_stb__tt__lg_ph.csv" phase(getData("loopGain" ?result "stb"))))
    errset(mtxDump("/home/mseminario2/vestarv/implementations/asic/castalia/analog/data/raw/amp_stb__tt__pm.csv" getData("phaseMargin" ?result "stb_margin")))
    errset(mtxDump("/home/mseminario2/vestarv/implementations/asic/castalia/analog/data/raw/amp_stb__tt__ugf.csv" cross(dB20(getData("loopGain" ?result "stb")) 0 1 "falling")))
  )
)

;; ---- corner 1 (tt) / test drive_dc
when(isDir("/home/mseminario2/chips/castalia/simarchive/anatop_tb_tia/tia_2026-07-28/Interactive.9/1/DriveTB/psf")
  openResults("/home/mseminario2/chips/castalia/simarchive/anatop_tb_tia/tia_2026-07-28/Interactive.9/1/DriveTB/psf")
  when(member('dc results())
    selectResult('dc)
    mtxP = outfile("/home/mseminario2/vestarv/implementations/asic/castalia/analog/data/raw/drive_dc__tt.meta" "w")
    fprintf(mtxP "sweep %%L\n" car(errset(sweepNames())))
    close(mtxP)
    errset(mtxDump("/home/mseminario2/vestarv/implementations/asic/castalia/analog/data/raw/drive_dc__tt__i_src.csv" cross(VS("/V_OutOL") 1.2375 1 "falling")))
    errset(mtxDump("/home/mseminario2/vestarv/implementations/asic/castalia/analog/data/raw/drive_dc__tt__vo.csv" VS("/V_OutOL")))
    errset(mtxDump("/home/mseminario2/vestarv/implementations/asic/castalia/analog/data/raw/drive_dc__tt__vo_snk40.csv" value(VS("/V_OutOL") -4e-05)))
    errset(mtxDump("/home/mseminario2/vestarv/implementations/asic/castalia/analog/data/raw/drive_dc__tt__vo_src40.csv" value(VS("/V_OutOL") 4e-05)))
  )
)

;; ---- corner 1 (tt) / test slew_tr
when(isDir("/home/mseminario2/chips/castalia/simarchive/anatop_tb_tia/tia_2026-07-28/Interactive.9/1/SlewOpenLoopTB/psf")
  openResults("/home/mseminario2/chips/castalia/simarchive/anatop_tb_tia/tia_2026-07-28/Interactive.9/1/SlewOpenLoopTB/psf")
  when(member('tran results())
    selectResult('tran)
    mtxP = outfile("/home/mseminario2/vestarv/implementations/asic/castalia/analog/data/raw/slew_tr__tt.meta" "w")
    fprintf(mtxP "sweep %%L\n" car(errset(sweepNames())))
    close(mtxP)
    errset(mtxDump("/home/mseminario2/vestarv/implementations/asic/castalia/analog/data/raw/slew_tr__tt__sr_n.csv" abs(ymin(deriv(VT("/V_OutOL"))))))
    errset(mtxDump("/home/mseminario2/vestarv/implementations/asic/castalia/analog/data/raw/slew_tr__tt__sr_p.csv" ymax(deriv(VT("/V_OutOL")))))
    errset(mtxDump("/home/mseminario2/vestarv/implementations/asic/castalia/analog/data/raw/slew_tr__tt__vo.csv" VT("/V_OutOL")))
  )
)

;; ---- corner 1 (tt) / test step_tr
when(isDir("/home/mseminario2/chips/castalia/simarchive/anatop_tb_tia/tia_2026-07-28/Interactive.9/1/StepUnityFeedbackTB/psf")
  openResults("/home/mseminario2/chips/castalia/simarchive/anatop_tb_tia/tia_2026-07-28/Interactive.9/1/StepUnityFeedbackTB/psf")
  when(member('tran results())
    selectResult('tran)
    mtxP = outfile("/home/mseminario2/vestarv/implementations/asic/castalia/analog/data/raw/step_tr__tt.meta" "w")
    fprintf(mtxP "sweep %%L\n" car(errset(sweepNames())))
    close(mtxP)
    errset(mtxDump("/home/mseminario2/vestarv/implementations/asic/castalia/analog/data/raw/step_tr__tt__err_1us.csv" ((value(VT("/V_OutOL") 101e-06) - value(VT("/V_OutOL") 500e-06)) * 1000.0)))
    errset(mtxDump("/home/mseminario2/vestarv/implementations/asic/castalia/analog/data/raw/step_tr__tt__ovs.csv" ((ymax(VT("/V_OutOL")) - (VAR("V_CM")+0.5)) * 100.0)))
    errset(mtxDump("/home/mseminario2/vestarv/implementations/asic/castalia/analog/data/raw/step_tr__tt__t_pk.csv" ((xmax(VT("/V_OutOL") 1) - 100e-06) * 1000000.0)))
    errset(mtxDump("/home/mseminario2/vestarv/implementations/asic/castalia/analog/data/raw/step_tr__tt__und.csv" (((VAR("V_CM")-0.5) - ymin(VT("/V_OutOL"))) * 100.0)))
    errset(mtxDump("/home/mseminario2/vestarv/implementations/asic/castalia/analog/data/raw/step_tr__tt__vo.csv" VT("/V_OutOL")))
  )
)

;; ---- corner 1 (tt) / test tia_ac
when(isDir("/home/mseminario2/chips/castalia/simarchive/anatop_tb_tia/tia_2026-07-28/Interactive.9/1/TiaFbTB/psf")
  openResults("/home/mseminario2/chips/castalia/simarchive/anatop_tb_tia/tia_2026-07-28/Interactive.9/1/TiaFbTB/psf")
  when(member('ac results())
    selectResult('ac)
    mtxP = outfile("/home/mseminario2/vestarv/implementations/asic/castalia/analog/data/raw/tia_ac__tt.meta" "w")
    fprintf(mtxP "sweep %%L\n" car(errset(sweepNames())))
    close(mtxP)
    errset(mtxDump("/home/mseminario2/vestarv/implementations/asic/castalia/analog/data/raw/tia_ac__tt__f3db.csv" bandwidth(VF("/V_OUT") 3 "low")))
    errset(mtxDump("/home/mseminario2/vestarv/implementations/asic/castalia/analog/data/raw/tia_ac__tt__f_pk.csv" xmax(mag(VF("/V_OUT")) 1)))
    errset(mtxDump("/home/mseminario2/vestarv/implementations/asic/castalia/analog/data/raw/tia_ac__tt__peak_db.csv" (ymax(dB20(VF("/V_OUT"))) - value(dB20(VF("/V_OUT")) 1))))
    errset(mtxDump("/home/mseminario2/vestarv/implementations/asic/castalia/analog/data/raw/tia_ac__tt__zin.csv" value(mag(VF("/WE")) 1)))
    errset(mtxDump("/home/mseminario2/vestarv/implementations/asic/castalia/analog/data/raw/tia_ac__tt__zt.csv" mag(VF("/V_OUT"))))
    errset(mtxDump("/home/mseminario2/vestarv/implementations/asic/castalia/analog/data/raw/tia_ac__tt__zt_dc.csv" value(mag(VF("/V_OUT")) 1)))
    errset(mtxDump("/home/mseminario2/vestarv/implementations/asic/castalia/analog/data/raw/tia_ac__tt__zt_pk.csv" ymax(mag(VF("/V_OUT")))))
  )
)

;; ---- corner 1 (tt) / test tia_dc
when(isDir("/home/mseminario2/chips/castalia/simarchive/anatop_tb_tia/tia_2026-07-28/Interactive.9/1/TiaFbTB/psf")
  openResults("/home/mseminario2/chips/castalia/simarchive/anatop_tb_tia/tia_2026-07-28/Interactive.9/1/TiaFbTB/psf")
  when(member('dc results())
    selectResult('dc)
    mtxP = outfile("/home/mseminario2/vestarv/implementations/asic/castalia/analog/data/raw/tia_dc__tt.meta" "w")
    fprintf(mtxP "sweep %%L\n" car(errset(sweepNames())))
    close(mtxP)
    errset(mtxDump("/home/mseminario2/vestarv/implementations/asic/castalia/analog/data/raw/tia_dc__tt__idd.csv" value(abs(IDC("/POWER/SRC_VDD25/PLUS")) 0)))
    errset(mtxDump("/home/mseminario2/vestarv/implementations/asic/castalia/analog/data/raw/tia_dc__tt__rt_0.csv" value(deriv(VS("/V_OUT")) 0)))
    errset(mtxDump("/home/mseminario2/vestarv/implementations/asic/castalia/analog/data/raw/tia_dc__tt__rt_2u.csv" value(deriv(VS("/V_OUT")) 2e-06)))
    errset(mtxDump("/home/mseminario2/vestarv/implementations/asic/castalia/analog/data/raw/tia_dc__tt__vout.csv" VS("/V_OUT")))
    errset(mtxDump("/home/mseminario2/vestarv/implementations/asic/castalia/analog/data/raw/tia_dc__tt__vout_hi.csv" ymax(VS("/V_OUT"))))
    errset(mtxDump("/home/mseminario2/vestarv/implementations/asic/castalia/analog/data/raw/tia_dc__tt__vout_lo.csv" ymin(VS("/V_OUT"))))
    errset(mtxDump("/home/mseminario2/vestarv/implementations/asic/castalia/analog/data/raw/tia_dc__tt__we_err.csv" (VS("/WE") - VS("/V_CM"))))
    errset(mtxDump("/home/mseminario2/vestarv/implementations/asic/castalia/analog/data/raw/tia_dc__tt__we_err_0.csv" value((VS("/WE") - VS("/V_CM")) 0)))
    errset(mtxDump("/home/mseminario2/vestarv/implementations/asic/castalia/analog/data/raw/tia_dc__tt__we_err_n2u.csv" value((VS("/WE") - VS("/V_CM")) -2e-06)))
    errset(mtxDump("/home/mseminario2/vestarv/implementations/asic/castalia/analog/data/raw/tia_dc__tt__we_err_p2u.csv" value((VS("/WE") - VS("/V_CM")) 2e-06)))
  )
)

;; ---- corner 2 (ff) / test amp_dc
when(isDir("/home/mseminario2/chips/castalia/simarchive/anatop_tb_tia/tia_2026-07-28/Interactive.9/2/UnityFeedbackTB/psf")
  openResults("/home/mseminario2/chips/castalia/simarchive/anatop_tb_tia/tia_2026-07-28/Interactive.9/2/UnityFeedbackTB/psf")
  when(member('dc results())
    selectResult('dc)
    mtxP = outfile("/home/mseminario2/vestarv/implementations/asic/castalia/analog/data/raw/amp_dc__ff.meta" "w")
    fprintf(mtxP "sweep %%L\n" car(errset(sweepNames())))
    close(mtxP)
    errset(mtxDump("/home/mseminario2/vestarv/implementations/asic/castalia/analog/data/raw/amp_dc__ff__cm_hi.csv" cross(abs(VS("/V_OutOL")-VS("/V_InP")) 0.002 1 "rising")))
    errset(mtxDump("/home/mseminario2/vestarv/implementations/asic/castalia/analog/data/raw/amp_dc__ff__cm_lo.csv" cross(abs(VS("/V_OutOL")-VS("/V_InP")) 0.002 1 "falling")))
    errset(mtxDump("/home/mseminario2/vestarv/implementations/asic/castalia/analog/data/raw/amp_dc__ff__track_err.csv" value(abs(VS("/V_OutOL")-VS("/V_InP")) 1.25)))
    errset(mtxDump("/home/mseminario2/vestarv/implementations/asic/castalia/analog/data/raw/amp_dc__ff__vos.csv" value((VS("/V_OutOL") - VS("/V_InP")) 1.25)))
  )
)

;; ---- corner 2 (ff) / test amp_noise
when(isDir("/home/mseminario2/chips/castalia/simarchive/anatop_tb_tia/tia_2026-07-28/Interactive.9/2/UnityFeedbackTB/psf")
  openResults("/home/mseminario2/chips/castalia/simarchive/anatop_tb_tia/tia_2026-07-28/Interactive.9/2/UnityFeedbackTB/psf")
  when(member('noise results())
    selectResult('noise)
    mtxP = outfile("/home/mseminario2/vestarv/implementations/asic/castalia/analog/data/raw/amp_noise__ff.meta" "w")
    fprintf(mtxP "sweep %%L\n" car(errset(sweepNames())))
    close(mtxP)
    errset(mtxDump("/home/mseminario2/vestarv/implementations/asic/castalia/analog/data/raw/amp_noise__ff__vn_10.csv" value(getData("in" ?result "noise") 10.0)))
    errset(mtxDump("/home/mseminario2/vestarv/implementations/asic/castalia/analog/data/raw/amp_noise__ff__vn_100.csv" value(getData("in" ?result "noise") 100.0)))
    errset(mtxDump("/home/mseminario2/vestarv/implementations/asic/castalia/analog/data/raw/amp_noise__ff__vn_1k.csv" value(getData("in" ?result "noise") 1000.0)))
    errset(mtxDump("/home/mseminario2/vestarv/implementations/asic/castalia/analog/data/raw/amp_noise__ff__vn_int.csv" sqrt(integ(getData("in" ?result "noise")**2 0.1 1700.0))))
  )
)

;; ---- corner 2 (ff) / test amp_op
when(isDir("/home/mseminario2/chips/castalia/simarchive/anatop_tb_tia/tia_2026-07-28/Interactive.9/2/UnityFeedbackTB/psf")
  openResults("/home/mseminario2/chips/castalia/simarchive/anatop_tb_tia/tia_2026-07-28/Interactive.9/2/UnityFeedbackTB/psf")
  when(member('dcOpInfo results())
    selectResult('dcOpInfo)
    mtxP = outfile("/home/mseminario2/vestarv/implementations/asic/castalia/analog/data/raw/amp_op__ff.meta" "w")
    fprintf(mtxP "sweep %%L\n" car(errset(sweepNames())))
    close(mtxP)
    errset(mtxDump("/home/mseminario2/vestarv/implementations/asic/castalia/analog/data/raw/amp_op__ff__a0_pred.csv" dB20((OP("/OPAMP/M4" "gm")/(OP("/OPAMP/M4" "gds")+OP("/OPAMP/M11" "gds")))*(OP("/OPAMP/M12" "gm")/(OP("/OPAMP/M12" "gds")+OP("/OPAMP/M5" "gds"))))))
    errset(mtxDump("/home/mseminario2/vestarv/implementations/asic/castalia/analog/data/raw/amp_op__ff__cc.csv" OP("/OPAMP/C0" "cap")))
    errset(mtxDump("/home/mseminario2/vestarv/implementations/asic/castalia/analog/data/raw/amp_op__ff__fp1_pred.csv" 1.0/(2*3.14159265358979*(1.0/(OP("/OPAMP/M4" "gds")+OP("/OPAMP/M11" "gds")))*(OP("/OPAMP/M12" "gm")/(OP("/OPAMP/M12" "gds")+OP("/OPAMP/M5" "gds")))*OP("/OPAMP/C0" "cap"))))
    errset(mtxDump("/home/mseminario2/vestarv/implementations/asic/castalia/analog/data/raw/amp_op__ff__fp2_pred.csv" OP("/OPAMP/M12" "gm")/(2*3.14159265358979*VAR("C_L"))))
    errset(mtxDump("/home/mseminario2/vestarv/implementations/asic/castalia/analog/data/raw/amp_op__ff__fu_pred.csv" OP("/OPAMP/M4" "gm")/(2*3.14159265358979*OP("/OPAMP/C0" "cap"))))
    errset(mtxDump("/home/mseminario2/vestarv/implementations/asic/castalia/analog/data/raw/amp_op__ff__gm1.csv" OP("/OPAMP/M4" "gm")))
    errset(mtxDump("/home/mseminario2/vestarv/implementations/asic/castalia/analog/data/raw/amp_op__ff__gm2.csv" OP("/OPAMP/M12" "gm")))
    errset(mtxDump("/home/mseminario2/vestarv/implementations/asic/castalia/analog/data/raw/amp_op__ff__itail.csv" abs(OP("/OPAMP/M2" "id"))))
    errset(mtxDump("/home/mseminario2/vestarv/implementations/asic/castalia/analog/data/raw/amp_op__ff__r1.csv" 1.0/(OP("/OPAMP/M4" "gds")+OP("/OPAMP/M11" "gds"))))
    errset(mtxDump("/home/mseminario2/vestarv/implementations/asic/castalia/analog/data/raw/amp_op__ff__r2.csv" 1.0/(OP("/OPAMP/M12" "gds")+OP("/OPAMP/M5" "gds"))))
  )
)

;; ---- corner 2 (ff) / test amp_stb
when(isDir("/home/mseminario2/chips/castalia/simarchive/anatop_tb_tia/tia_2026-07-28/Interactive.9/2/UnityFeedbackTB/psf")
  openResults("/home/mseminario2/chips/castalia/simarchive/anatop_tb_tia/tia_2026-07-28/Interactive.9/2/UnityFeedbackTB/psf")
  when(member('stb results())
    selectResult('stb)
    mtxP = outfile("/home/mseminario2/vestarv/implementations/asic/castalia/analog/data/raw/amp_stb__ff.meta" "w")
    fprintf(mtxP "sweep %%L\n" car(errset(sweepNames())))
    close(mtxP)
    errset(mtxDump("/home/mseminario2/vestarv/implementations/asic/castalia/analog/data/raw/amp_stb__ff__a0.csv" ymax(dB20(getData("loopGain" ?result "stb")))))
    errset(mtxDump("/home/mseminario2/vestarv/implementations/asic/castalia/analog/data/raw/amp_stb__ff__fp1_meas.csv" bandwidth(getData("loopGain" ?result "stb") 3 "low")))
    errset(mtxDump("/home/mseminario2/vestarv/implementations/asic/castalia/analog/data/raw/amp_stb__ff__gm.csv" getData("gainMargin" ?result "stb_margin")))
    errset(mtxDump("/home/mseminario2/vestarv/implementations/asic/castalia/analog/data/raw/amp_stb__ff__lg_db.csv" dB20(getData("loopGain" ?result "stb"))))
    errset(mtxDump("/home/mseminario2/vestarv/implementations/asic/castalia/analog/data/raw/amp_stb__ff__lg_ph.csv" phase(getData("loopGain" ?result "stb"))))
    errset(mtxDump("/home/mseminario2/vestarv/implementations/asic/castalia/analog/data/raw/amp_stb__ff__pm.csv" getData("phaseMargin" ?result "stb_margin")))
    errset(mtxDump("/home/mseminario2/vestarv/implementations/asic/castalia/analog/data/raw/amp_stb__ff__ugf.csv" cross(dB20(getData("loopGain" ?result "stb")) 0 1 "falling")))
  )
)

;; ---- corner 2 (ff) / test drive_dc
when(isDir("/home/mseminario2/chips/castalia/simarchive/anatop_tb_tia/tia_2026-07-28/Interactive.9/2/DriveTB/psf")
  openResults("/home/mseminario2/chips/castalia/simarchive/anatop_tb_tia/tia_2026-07-28/Interactive.9/2/DriveTB/psf")
  when(member('dc results())
    selectResult('dc)
    mtxP = outfile("/home/mseminario2/vestarv/implementations/asic/castalia/analog/data/raw/drive_dc__ff.meta" "w")
    fprintf(mtxP "sweep %%L\n" car(errset(sweepNames())))
    close(mtxP)
    errset(mtxDump("/home/mseminario2/vestarv/implementations/asic/castalia/analog/data/raw/drive_dc__ff__i_src.csv" cross(VS("/V_OutOL") 1.2375 1 "falling")))
    errset(mtxDump("/home/mseminario2/vestarv/implementations/asic/castalia/analog/data/raw/drive_dc__ff__vo.csv" VS("/V_OutOL")))
    errset(mtxDump("/home/mseminario2/vestarv/implementations/asic/castalia/analog/data/raw/drive_dc__ff__vo_snk40.csv" value(VS("/V_OutOL") -4e-05)))
    errset(mtxDump("/home/mseminario2/vestarv/implementations/asic/castalia/analog/data/raw/drive_dc__ff__vo_src40.csv" value(VS("/V_OutOL") 4e-05)))
  )
)

;; ---- corner 2 (ff) / test slew_tr
when(isDir("/home/mseminario2/chips/castalia/simarchive/anatop_tb_tia/tia_2026-07-28/Interactive.9/2/SlewOpenLoopTB/psf")
  openResults("/home/mseminario2/chips/castalia/simarchive/anatop_tb_tia/tia_2026-07-28/Interactive.9/2/SlewOpenLoopTB/psf")
  when(member('tran results())
    selectResult('tran)
    mtxP = outfile("/home/mseminario2/vestarv/implementations/asic/castalia/analog/data/raw/slew_tr__ff.meta" "w")
    fprintf(mtxP "sweep %%L\n" car(errset(sweepNames())))
    close(mtxP)
    errset(mtxDump("/home/mseminario2/vestarv/implementations/asic/castalia/analog/data/raw/slew_tr__ff__sr_n.csv" abs(ymin(deriv(VT("/V_OutOL"))))))
    errset(mtxDump("/home/mseminario2/vestarv/implementations/asic/castalia/analog/data/raw/slew_tr__ff__sr_p.csv" ymax(deriv(VT("/V_OutOL")))))
    errset(mtxDump("/home/mseminario2/vestarv/implementations/asic/castalia/analog/data/raw/slew_tr__ff__vo.csv" VT("/V_OutOL")))
  )
)

;; ---- corner 2 (ff) / test step_tr
when(isDir("/home/mseminario2/chips/castalia/simarchive/anatop_tb_tia/tia_2026-07-28/Interactive.9/2/StepUnityFeedbackTB/psf")
  openResults("/home/mseminario2/chips/castalia/simarchive/anatop_tb_tia/tia_2026-07-28/Interactive.9/2/StepUnityFeedbackTB/psf")
  when(member('tran results())
    selectResult('tran)
    mtxP = outfile("/home/mseminario2/vestarv/implementations/asic/castalia/analog/data/raw/step_tr__ff.meta" "w")
    fprintf(mtxP "sweep %%L\n" car(errset(sweepNames())))
    close(mtxP)
    errset(mtxDump("/home/mseminario2/vestarv/implementations/asic/castalia/analog/data/raw/step_tr__ff__err_1us.csv" ((value(VT("/V_OutOL") 101e-06) - value(VT("/V_OutOL") 500e-06)) * 1000.0)))
    errset(mtxDump("/home/mseminario2/vestarv/implementations/asic/castalia/analog/data/raw/step_tr__ff__ovs.csv" ((ymax(VT("/V_OutOL")) - (VAR("V_CM")+0.5)) * 100.0)))
    errset(mtxDump("/home/mseminario2/vestarv/implementations/asic/castalia/analog/data/raw/step_tr__ff__t_pk.csv" ((xmax(VT("/V_OutOL") 1) - 100e-06) * 1000000.0)))
    errset(mtxDump("/home/mseminario2/vestarv/implementations/asic/castalia/analog/data/raw/step_tr__ff__und.csv" (((VAR("V_CM")-0.5) - ymin(VT("/V_OutOL"))) * 100.0)))
    errset(mtxDump("/home/mseminario2/vestarv/implementations/asic/castalia/analog/data/raw/step_tr__ff__vo.csv" VT("/V_OutOL")))
  )
)

;; ---- corner 2 (ff) / test tia_ac
when(isDir("/home/mseminario2/chips/castalia/simarchive/anatop_tb_tia/tia_2026-07-28/Interactive.9/2/TiaFbTB/psf")
  openResults("/home/mseminario2/chips/castalia/simarchive/anatop_tb_tia/tia_2026-07-28/Interactive.9/2/TiaFbTB/psf")
  when(member('ac results())
    selectResult('ac)
    mtxP = outfile("/home/mseminario2/vestarv/implementations/asic/castalia/analog/data/raw/tia_ac__ff.meta" "w")
    fprintf(mtxP "sweep %%L\n" car(errset(sweepNames())))
    close(mtxP)
    errset(mtxDump("/home/mseminario2/vestarv/implementations/asic/castalia/analog/data/raw/tia_ac__ff__f3db.csv" bandwidth(VF("/V_OUT") 3 "low")))
    errset(mtxDump("/home/mseminario2/vestarv/implementations/asic/castalia/analog/data/raw/tia_ac__ff__f_pk.csv" xmax(mag(VF("/V_OUT")) 1)))
    errset(mtxDump("/home/mseminario2/vestarv/implementations/asic/castalia/analog/data/raw/tia_ac__ff__peak_db.csv" (ymax(dB20(VF("/V_OUT"))) - value(dB20(VF("/V_OUT")) 1))))
    errset(mtxDump("/home/mseminario2/vestarv/implementations/asic/castalia/analog/data/raw/tia_ac__ff__zin.csv" value(mag(VF("/WE")) 1)))
    errset(mtxDump("/home/mseminario2/vestarv/implementations/asic/castalia/analog/data/raw/tia_ac__ff__zt.csv" mag(VF("/V_OUT"))))
    errset(mtxDump("/home/mseminario2/vestarv/implementations/asic/castalia/analog/data/raw/tia_ac__ff__zt_dc.csv" value(mag(VF("/V_OUT")) 1)))
    errset(mtxDump("/home/mseminario2/vestarv/implementations/asic/castalia/analog/data/raw/tia_ac__ff__zt_pk.csv" ymax(mag(VF("/V_OUT")))))
  )
)

;; ---- corner 2 (ff) / test tia_dc
when(isDir("/home/mseminario2/chips/castalia/simarchive/anatop_tb_tia/tia_2026-07-28/Interactive.9/2/TiaFbTB/psf")
  openResults("/home/mseminario2/chips/castalia/simarchive/anatop_tb_tia/tia_2026-07-28/Interactive.9/2/TiaFbTB/psf")
  when(member('dc results())
    selectResult('dc)
    mtxP = outfile("/home/mseminario2/vestarv/implementations/asic/castalia/analog/data/raw/tia_dc__ff.meta" "w")
    fprintf(mtxP "sweep %%L\n" car(errset(sweepNames())))
    close(mtxP)
    errset(mtxDump("/home/mseminario2/vestarv/implementations/asic/castalia/analog/data/raw/tia_dc__ff__idd.csv" value(abs(IDC("/POWER/SRC_VDD25/PLUS")) 0)))
    errset(mtxDump("/home/mseminario2/vestarv/implementations/asic/castalia/analog/data/raw/tia_dc__ff__rt_0.csv" value(deriv(VS("/V_OUT")) 0)))
    errset(mtxDump("/home/mseminario2/vestarv/implementations/asic/castalia/analog/data/raw/tia_dc__ff__rt_2u.csv" value(deriv(VS("/V_OUT")) 2e-06)))
    errset(mtxDump("/home/mseminario2/vestarv/implementations/asic/castalia/analog/data/raw/tia_dc__ff__vout.csv" VS("/V_OUT")))
    errset(mtxDump("/home/mseminario2/vestarv/implementations/asic/castalia/analog/data/raw/tia_dc__ff__vout_hi.csv" ymax(VS("/V_OUT"))))
    errset(mtxDump("/home/mseminario2/vestarv/implementations/asic/castalia/analog/data/raw/tia_dc__ff__vout_lo.csv" ymin(VS("/V_OUT"))))
    errset(mtxDump("/home/mseminario2/vestarv/implementations/asic/castalia/analog/data/raw/tia_dc__ff__we_err.csv" (VS("/WE") - VS("/V_CM"))))
    errset(mtxDump("/home/mseminario2/vestarv/implementations/asic/castalia/analog/data/raw/tia_dc__ff__we_err_0.csv" value((VS("/WE") - VS("/V_CM")) 0)))
    errset(mtxDump("/home/mseminario2/vestarv/implementations/asic/castalia/analog/data/raw/tia_dc__ff__we_err_n2u.csv" value((VS("/WE") - VS("/V_CM")) -2e-06)))
    errset(mtxDump("/home/mseminario2/vestarv/implementations/asic/castalia/analog/data/raw/tia_dc__ff__we_err_p2u.csv" value((VS("/WE") - VS("/V_CM")) 2e-06)))
  )
)

;; ---- corner 3 (fs) / test amp_dc
when(isDir("/home/mseminario2/chips/castalia/simarchive/anatop_tb_tia/tia_2026-07-28/Interactive.9/3/UnityFeedbackTB/psf")
  openResults("/home/mseminario2/chips/castalia/simarchive/anatop_tb_tia/tia_2026-07-28/Interactive.9/3/UnityFeedbackTB/psf")
  when(member('dc results())
    selectResult('dc)
    mtxP = outfile("/home/mseminario2/vestarv/implementations/asic/castalia/analog/data/raw/amp_dc__fs.meta" "w")
    fprintf(mtxP "sweep %%L\n" car(errset(sweepNames())))
    close(mtxP)
    errset(mtxDump("/home/mseminario2/vestarv/implementations/asic/castalia/analog/data/raw/amp_dc__fs__cm_hi.csv" cross(abs(VS("/V_OutOL")-VS("/V_InP")) 0.002 1 "rising")))
    errset(mtxDump("/home/mseminario2/vestarv/implementations/asic/castalia/analog/data/raw/amp_dc__fs__cm_lo.csv" cross(abs(VS("/V_OutOL")-VS("/V_InP")) 0.002 1 "falling")))
    errset(mtxDump("/home/mseminario2/vestarv/implementations/asic/castalia/analog/data/raw/amp_dc__fs__track_err.csv" value(abs(VS("/V_OutOL")-VS("/V_InP")) 1.25)))
    errset(mtxDump("/home/mseminario2/vestarv/implementations/asic/castalia/analog/data/raw/amp_dc__fs__vos.csv" value((VS("/V_OutOL") - VS("/V_InP")) 1.25)))
  )
)

;; ---- corner 3 (fs) / test amp_noise
when(isDir("/home/mseminario2/chips/castalia/simarchive/anatop_tb_tia/tia_2026-07-28/Interactive.9/3/UnityFeedbackTB/psf")
  openResults("/home/mseminario2/chips/castalia/simarchive/anatop_tb_tia/tia_2026-07-28/Interactive.9/3/UnityFeedbackTB/psf")
  when(member('noise results())
    selectResult('noise)
    mtxP = outfile("/home/mseminario2/vestarv/implementations/asic/castalia/analog/data/raw/amp_noise__fs.meta" "w")
    fprintf(mtxP "sweep %%L\n" car(errset(sweepNames())))
    close(mtxP)
    errset(mtxDump("/home/mseminario2/vestarv/implementations/asic/castalia/analog/data/raw/amp_noise__fs__vn_10.csv" value(getData("in" ?result "noise") 10.0)))
    errset(mtxDump("/home/mseminario2/vestarv/implementations/asic/castalia/analog/data/raw/amp_noise__fs__vn_100.csv" value(getData("in" ?result "noise") 100.0)))
    errset(mtxDump("/home/mseminario2/vestarv/implementations/asic/castalia/analog/data/raw/amp_noise__fs__vn_1k.csv" value(getData("in" ?result "noise") 1000.0)))
    errset(mtxDump("/home/mseminario2/vestarv/implementations/asic/castalia/analog/data/raw/amp_noise__fs__vn_int.csv" sqrt(integ(getData("in" ?result "noise")**2 0.1 1700.0))))
  )
)

;; ---- corner 3 (fs) / test amp_op
when(isDir("/home/mseminario2/chips/castalia/simarchive/anatop_tb_tia/tia_2026-07-28/Interactive.9/3/UnityFeedbackTB/psf")
  openResults("/home/mseminario2/chips/castalia/simarchive/anatop_tb_tia/tia_2026-07-28/Interactive.9/3/UnityFeedbackTB/psf")
  when(member('dcOpInfo results())
    selectResult('dcOpInfo)
    mtxP = outfile("/home/mseminario2/vestarv/implementations/asic/castalia/analog/data/raw/amp_op__fs.meta" "w")
    fprintf(mtxP "sweep %%L\n" car(errset(sweepNames())))
    close(mtxP)
    errset(mtxDump("/home/mseminario2/vestarv/implementations/asic/castalia/analog/data/raw/amp_op__fs__a0_pred.csv" dB20((OP("/OPAMP/M4" "gm")/(OP("/OPAMP/M4" "gds")+OP("/OPAMP/M11" "gds")))*(OP("/OPAMP/M12" "gm")/(OP("/OPAMP/M12" "gds")+OP("/OPAMP/M5" "gds"))))))
    errset(mtxDump("/home/mseminario2/vestarv/implementations/asic/castalia/analog/data/raw/amp_op__fs__cc.csv" OP("/OPAMP/C0" "cap")))
    errset(mtxDump("/home/mseminario2/vestarv/implementations/asic/castalia/analog/data/raw/amp_op__fs__fp1_pred.csv" 1.0/(2*3.14159265358979*(1.0/(OP("/OPAMP/M4" "gds")+OP("/OPAMP/M11" "gds")))*(OP("/OPAMP/M12" "gm")/(OP("/OPAMP/M12" "gds")+OP("/OPAMP/M5" "gds")))*OP("/OPAMP/C0" "cap"))))
    errset(mtxDump("/home/mseminario2/vestarv/implementations/asic/castalia/analog/data/raw/amp_op__fs__fp2_pred.csv" OP("/OPAMP/M12" "gm")/(2*3.14159265358979*VAR("C_L"))))
    errset(mtxDump("/home/mseminario2/vestarv/implementations/asic/castalia/analog/data/raw/amp_op__fs__fu_pred.csv" OP("/OPAMP/M4" "gm")/(2*3.14159265358979*OP("/OPAMP/C0" "cap"))))
    errset(mtxDump("/home/mseminario2/vestarv/implementations/asic/castalia/analog/data/raw/amp_op__fs__gm1.csv" OP("/OPAMP/M4" "gm")))
    errset(mtxDump("/home/mseminario2/vestarv/implementations/asic/castalia/analog/data/raw/amp_op__fs__gm2.csv" OP("/OPAMP/M12" "gm")))
    errset(mtxDump("/home/mseminario2/vestarv/implementations/asic/castalia/analog/data/raw/amp_op__fs__itail.csv" abs(OP("/OPAMP/M2" "id"))))
    errset(mtxDump("/home/mseminario2/vestarv/implementations/asic/castalia/analog/data/raw/amp_op__fs__r1.csv" 1.0/(OP("/OPAMP/M4" "gds")+OP("/OPAMP/M11" "gds"))))
    errset(mtxDump("/home/mseminario2/vestarv/implementations/asic/castalia/analog/data/raw/amp_op__fs__r2.csv" 1.0/(OP("/OPAMP/M12" "gds")+OP("/OPAMP/M5" "gds"))))
  )
)

;; ---- corner 3 (fs) / test amp_stb
when(isDir("/home/mseminario2/chips/castalia/simarchive/anatop_tb_tia/tia_2026-07-28/Interactive.9/3/UnityFeedbackTB/psf")
  openResults("/home/mseminario2/chips/castalia/simarchive/anatop_tb_tia/tia_2026-07-28/Interactive.9/3/UnityFeedbackTB/psf")
  when(member('stb results())
    selectResult('stb)
    mtxP = outfile("/home/mseminario2/vestarv/implementations/asic/castalia/analog/data/raw/amp_stb__fs.meta" "w")
    fprintf(mtxP "sweep %%L\n" car(errset(sweepNames())))
    close(mtxP)
    errset(mtxDump("/home/mseminario2/vestarv/implementations/asic/castalia/analog/data/raw/amp_stb__fs__a0.csv" ymax(dB20(getData("loopGain" ?result "stb")))))
    errset(mtxDump("/home/mseminario2/vestarv/implementations/asic/castalia/analog/data/raw/amp_stb__fs__fp1_meas.csv" bandwidth(getData("loopGain" ?result "stb") 3 "low")))
    errset(mtxDump("/home/mseminario2/vestarv/implementations/asic/castalia/analog/data/raw/amp_stb__fs__gm.csv" getData("gainMargin" ?result "stb_margin")))
    errset(mtxDump("/home/mseminario2/vestarv/implementations/asic/castalia/analog/data/raw/amp_stb__fs__lg_db.csv" dB20(getData("loopGain" ?result "stb"))))
    errset(mtxDump("/home/mseminario2/vestarv/implementations/asic/castalia/analog/data/raw/amp_stb__fs__lg_ph.csv" phase(getData("loopGain" ?result "stb"))))
    errset(mtxDump("/home/mseminario2/vestarv/implementations/asic/castalia/analog/data/raw/amp_stb__fs__pm.csv" getData("phaseMargin" ?result "stb_margin")))
    errset(mtxDump("/home/mseminario2/vestarv/implementations/asic/castalia/analog/data/raw/amp_stb__fs__ugf.csv" cross(dB20(getData("loopGain" ?result "stb")) 0 1 "falling")))
  )
)

;; ---- corner 3 (fs) / test drive_dc
when(isDir("/home/mseminario2/chips/castalia/simarchive/anatop_tb_tia/tia_2026-07-28/Interactive.9/3/DriveTB/psf")
  openResults("/home/mseminario2/chips/castalia/simarchive/anatop_tb_tia/tia_2026-07-28/Interactive.9/3/DriveTB/psf")
  when(member('dc results())
    selectResult('dc)
    mtxP = outfile("/home/mseminario2/vestarv/implementations/asic/castalia/analog/data/raw/drive_dc__fs.meta" "w")
    fprintf(mtxP "sweep %%L\n" car(errset(sweepNames())))
    close(mtxP)
    errset(mtxDump("/home/mseminario2/vestarv/implementations/asic/castalia/analog/data/raw/drive_dc__fs__i_src.csv" cross(VS("/V_OutOL") 1.2375 1 "falling")))
    errset(mtxDump("/home/mseminario2/vestarv/implementations/asic/castalia/analog/data/raw/drive_dc__fs__vo.csv" VS("/V_OutOL")))
    errset(mtxDump("/home/mseminario2/vestarv/implementations/asic/castalia/analog/data/raw/drive_dc__fs__vo_snk40.csv" value(VS("/V_OutOL") -4e-05)))
    errset(mtxDump("/home/mseminario2/vestarv/implementations/asic/castalia/analog/data/raw/drive_dc__fs__vo_src40.csv" value(VS("/V_OutOL") 4e-05)))
  )
)

;; ---- corner 3 (fs) / test slew_tr
when(isDir("/home/mseminario2/chips/castalia/simarchive/anatop_tb_tia/tia_2026-07-28/Interactive.9/3/SlewOpenLoopTB/psf")
  openResults("/home/mseminario2/chips/castalia/simarchive/anatop_tb_tia/tia_2026-07-28/Interactive.9/3/SlewOpenLoopTB/psf")
  when(member('tran results())
    selectResult('tran)
    mtxP = outfile("/home/mseminario2/vestarv/implementations/asic/castalia/analog/data/raw/slew_tr__fs.meta" "w")
    fprintf(mtxP "sweep %%L\n" car(errset(sweepNames())))
    close(mtxP)
    errset(mtxDump("/home/mseminario2/vestarv/implementations/asic/castalia/analog/data/raw/slew_tr__fs__sr_n.csv" abs(ymin(deriv(VT("/V_OutOL"))))))
    errset(mtxDump("/home/mseminario2/vestarv/implementations/asic/castalia/analog/data/raw/slew_tr__fs__sr_p.csv" ymax(deriv(VT("/V_OutOL")))))
    errset(mtxDump("/home/mseminario2/vestarv/implementations/asic/castalia/analog/data/raw/slew_tr__fs__vo.csv" VT("/V_OutOL")))
  )
)

;; ---- corner 3 (fs) / test step_tr
when(isDir("/home/mseminario2/chips/castalia/simarchive/anatop_tb_tia/tia_2026-07-28/Interactive.9/3/StepUnityFeedbackTB/psf")
  openResults("/home/mseminario2/chips/castalia/simarchive/anatop_tb_tia/tia_2026-07-28/Interactive.9/3/StepUnityFeedbackTB/psf")
  when(member('tran results())
    selectResult('tran)
    mtxP = outfile("/home/mseminario2/vestarv/implementations/asic/castalia/analog/data/raw/step_tr__fs.meta" "w")
    fprintf(mtxP "sweep %%L\n" car(errset(sweepNames())))
    close(mtxP)
    errset(mtxDump("/home/mseminario2/vestarv/implementations/asic/castalia/analog/data/raw/step_tr__fs__err_1us.csv" ((value(VT("/V_OutOL") 101e-06) - value(VT("/V_OutOL") 500e-06)) * 1000.0)))
    errset(mtxDump("/home/mseminario2/vestarv/implementations/asic/castalia/analog/data/raw/step_tr__fs__ovs.csv" ((ymax(VT("/V_OutOL")) - (VAR("V_CM")+0.5)) * 100.0)))
    errset(mtxDump("/home/mseminario2/vestarv/implementations/asic/castalia/analog/data/raw/step_tr__fs__t_pk.csv" ((xmax(VT("/V_OutOL") 1) - 100e-06) * 1000000.0)))
    errset(mtxDump("/home/mseminario2/vestarv/implementations/asic/castalia/analog/data/raw/step_tr__fs__und.csv" (((VAR("V_CM")-0.5) - ymin(VT("/V_OutOL"))) * 100.0)))
    errset(mtxDump("/home/mseminario2/vestarv/implementations/asic/castalia/analog/data/raw/step_tr__fs__vo.csv" VT("/V_OutOL")))
  )
)

;; ---- corner 3 (fs) / test tia_ac
when(isDir("/home/mseminario2/chips/castalia/simarchive/anatop_tb_tia/tia_2026-07-28/Interactive.9/3/TiaFbTB/psf")
  openResults("/home/mseminario2/chips/castalia/simarchive/anatop_tb_tia/tia_2026-07-28/Interactive.9/3/TiaFbTB/psf")
  when(member('ac results())
    selectResult('ac)
    mtxP = outfile("/home/mseminario2/vestarv/implementations/asic/castalia/analog/data/raw/tia_ac__fs.meta" "w")
    fprintf(mtxP "sweep %%L\n" car(errset(sweepNames())))
    close(mtxP)
    errset(mtxDump("/home/mseminario2/vestarv/implementations/asic/castalia/analog/data/raw/tia_ac__fs__f3db.csv" bandwidth(VF("/V_OUT") 3 "low")))
    errset(mtxDump("/home/mseminario2/vestarv/implementations/asic/castalia/analog/data/raw/tia_ac__fs__f_pk.csv" xmax(mag(VF("/V_OUT")) 1)))
    errset(mtxDump("/home/mseminario2/vestarv/implementations/asic/castalia/analog/data/raw/tia_ac__fs__peak_db.csv" (ymax(dB20(VF("/V_OUT"))) - value(dB20(VF("/V_OUT")) 1))))
    errset(mtxDump("/home/mseminario2/vestarv/implementations/asic/castalia/analog/data/raw/tia_ac__fs__zin.csv" value(mag(VF("/WE")) 1)))
    errset(mtxDump("/home/mseminario2/vestarv/implementations/asic/castalia/analog/data/raw/tia_ac__fs__zt.csv" mag(VF("/V_OUT"))))
    errset(mtxDump("/home/mseminario2/vestarv/implementations/asic/castalia/analog/data/raw/tia_ac__fs__zt_dc.csv" value(mag(VF("/V_OUT")) 1)))
    errset(mtxDump("/home/mseminario2/vestarv/implementations/asic/castalia/analog/data/raw/tia_ac__fs__zt_pk.csv" ymax(mag(VF("/V_OUT")))))
  )
)

;; ---- corner 3 (fs) / test tia_dc
when(isDir("/home/mseminario2/chips/castalia/simarchive/anatop_tb_tia/tia_2026-07-28/Interactive.9/3/TiaFbTB/psf")
  openResults("/home/mseminario2/chips/castalia/simarchive/anatop_tb_tia/tia_2026-07-28/Interactive.9/3/TiaFbTB/psf")
  when(member('dc results())
    selectResult('dc)
    mtxP = outfile("/home/mseminario2/vestarv/implementations/asic/castalia/analog/data/raw/tia_dc__fs.meta" "w")
    fprintf(mtxP "sweep %%L\n" car(errset(sweepNames())))
    close(mtxP)
    errset(mtxDump("/home/mseminario2/vestarv/implementations/asic/castalia/analog/data/raw/tia_dc__fs__idd.csv" value(abs(IDC("/POWER/SRC_VDD25/PLUS")) 0)))
    errset(mtxDump("/home/mseminario2/vestarv/implementations/asic/castalia/analog/data/raw/tia_dc__fs__rt_0.csv" value(deriv(VS("/V_OUT")) 0)))
    errset(mtxDump("/home/mseminario2/vestarv/implementations/asic/castalia/analog/data/raw/tia_dc__fs__rt_2u.csv" value(deriv(VS("/V_OUT")) 2e-06)))
    errset(mtxDump("/home/mseminario2/vestarv/implementations/asic/castalia/analog/data/raw/tia_dc__fs__vout.csv" VS("/V_OUT")))
    errset(mtxDump("/home/mseminario2/vestarv/implementations/asic/castalia/analog/data/raw/tia_dc__fs__vout_hi.csv" ymax(VS("/V_OUT"))))
    errset(mtxDump("/home/mseminario2/vestarv/implementations/asic/castalia/analog/data/raw/tia_dc__fs__vout_lo.csv" ymin(VS("/V_OUT"))))
    errset(mtxDump("/home/mseminario2/vestarv/implementations/asic/castalia/analog/data/raw/tia_dc__fs__we_err.csv" (VS("/WE") - VS("/V_CM"))))
    errset(mtxDump("/home/mseminario2/vestarv/implementations/asic/castalia/analog/data/raw/tia_dc__fs__we_err_0.csv" value((VS("/WE") - VS("/V_CM")) 0)))
    errset(mtxDump("/home/mseminario2/vestarv/implementations/asic/castalia/analog/data/raw/tia_dc__fs__we_err_n2u.csv" value((VS("/WE") - VS("/V_CM")) -2e-06)))
    errset(mtxDump("/home/mseminario2/vestarv/implementations/asic/castalia/analog/data/raw/tia_dc__fs__we_err_p2u.csv" value((VS("/WE") - VS("/V_CM")) 2e-06)))
  )
)

;; ---- corner 4 (sf) / test amp_dc
when(isDir("/home/mseminario2/chips/castalia/simarchive/anatop_tb_tia/tia_2026-07-28/Interactive.9/4/UnityFeedbackTB/psf")
  openResults("/home/mseminario2/chips/castalia/simarchive/anatop_tb_tia/tia_2026-07-28/Interactive.9/4/UnityFeedbackTB/psf")
  when(member('dc results())
    selectResult('dc)
    mtxP = outfile("/home/mseminario2/vestarv/implementations/asic/castalia/analog/data/raw/amp_dc__sf.meta" "w")
    fprintf(mtxP "sweep %%L\n" car(errset(sweepNames())))
    close(mtxP)
    errset(mtxDump("/home/mseminario2/vestarv/implementations/asic/castalia/analog/data/raw/amp_dc__sf__cm_hi.csv" cross(abs(VS("/V_OutOL")-VS("/V_InP")) 0.002 1 "rising")))
    errset(mtxDump("/home/mseminario2/vestarv/implementations/asic/castalia/analog/data/raw/amp_dc__sf__cm_lo.csv" cross(abs(VS("/V_OutOL")-VS("/V_InP")) 0.002 1 "falling")))
    errset(mtxDump("/home/mseminario2/vestarv/implementations/asic/castalia/analog/data/raw/amp_dc__sf__track_err.csv" value(abs(VS("/V_OutOL")-VS("/V_InP")) 1.25)))
    errset(mtxDump("/home/mseminario2/vestarv/implementations/asic/castalia/analog/data/raw/amp_dc__sf__vos.csv" value((VS("/V_OutOL") - VS("/V_InP")) 1.25)))
  )
)

;; ---- corner 4 (sf) / test amp_noise
when(isDir("/home/mseminario2/chips/castalia/simarchive/anatop_tb_tia/tia_2026-07-28/Interactive.9/4/UnityFeedbackTB/psf")
  openResults("/home/mseminario2/chips/castalia/simarchive/anatop_tb_tia/tia_2026-07-28/Interactive.9/4/UnityFeedbackTB/psf")
  when(member('noise results())
    selectResult('noise)
    mtxP = outfile("/home/mseminario2/vestarv/implementations/asic/castalia/analog/data/raw/amp_noise__sf.meta" "w")
    fprintf(mtxP "sweep %%L\n" car(errset(sweepNames())))
    close(mtxP)
    errset(mtxDump("/home/mseminario2/vestarv/implementations/asic/castalia/analog/data/raw/amp_noise__sf__vn_10.csv" value(getData("in" ?result "noise") 10.0)))
    errset(mtxDump("/home/mseminario2/vestarv/implementations/asic/castalia/analog/data/raw/amp_noise__sf__vn_100.csv" value(getData("in" ?result "noise") 100.0)))
    errset(mtxDump("/home/mseminario2/vestarv/implementations/asic/castalia/analog/data/raw/amp_noise__sf__vn_1k.csv" value(getData("in" ?result "noise") 1000.0)))
    errset(mtxDump("/home/mseminario2/vestarv/implementations/asic/castalia/analog/data/raw/amp_noise__sf__vn_int.csv" sqrt(integ(getData("in" ?result "noise")**2 0.1 1700.0))))
  )
)

;; ---- corner 4 (sf) / test amp_op
when(isDir("/home/mseminario2/chips/castalia/simarchive/anatop_tb_tia/tia_2026-07-28/Interactive.9/4/UnityFeedbackTB/psf")
  openResults("/home/mseminario2/chips/castalia/simarchive/anatop_tb_tia/tia_2026-07-28/Interactive.9/4/UnityFeedbackTB/psf")
  when(member('dcOpInfo results())
    selectResult('dcOpInfo)
    mtxP = outfile("/home/mseminario2/vestarv/implementations/asic/castalia/analog/data/raw/amp_op__sf.meta" "w")
    fprintf(mtxP "sweep %%L\n" car(errset(sweepNames())))
    close(mtxP)
    errset(mtxDump("/home/mseminario2/vestarv/implementations/asic/castalia/analog/data/raw/amp_op__sf__a0_pred.csv" dB20((OP("/OPAMP/M4" "gm")/(OP("/OPAMP/M4" "gds")+OP("/OPAMP/M11" "gds")))*(OP("/OPAMP/M12" "gm")/(OP("/OPAMP/M12" "gds")+OP("/OPAMP/M5" "gds"))))))
    errset(mtxDump("/home/mseminario2/vestarv/implementations/asic/castalia/analog/data/raw/amp_op__sf__cc.csv" OP("/OPAMP/C0" "cap")))
    errset(mtxDump("/home/mseminario2/vestarv/implementations/asic/castalia/analog/data/raw/amp_op__sf__fp1_pred.csv" 1.0/(2*3.14159265358979*(1.0/(OP("/OPAMP/M4" "gds")+OP("/OPAMP/M11" "gds")))*(OP("/OPAMP/M12" "gm")/(OP("/OPAMP/M12" "gds")+OP("/OPAMP/M5" "gds")))*OP("/OPAMP/C0" "cap"))))
    errset(mtxDump("/home/mseminario2/vestarv/implementations/asic/castalia/analog/data/raw/amp_op__sf__fp2_pred.csv" OP("/OPAMP/M12" "gm")/(2*3.14159265358979*VAR("C_L"))))
    errset(mtxDump("/home/mseminario2/vestarv/implementations/asic/castalia/analog/data/raw/amp_op__sf__fu_pred.csv" OP("/OPAMP/M4" "gm")/(2*3.14159265358979*OP("/OPAMP/C0" "cap"))))
    errset(mtxDump("/home/mseminario2/vestarv/implementations/asic/castalia/analog/data/raw/amp_op__sf__gm1.csv" OP("/OPAMP/M4" "gm")))
    errset(mtxDump("/home/mseminario2/vestarv/implementations/asic/castalia/analog/data/raw/amp_op__sf__gm2.csv" OP("/OPAMP/M12" "gm")))
    errset(mtxDump("/home/mseminario2/vestarv/implementations/asic/castalia/analog/data/raw/amp_op__sf__itail.csv" abs(OP("/OPAMP/M2" "id"))))
    errset(mtxDump("/home/mseminario2/vestarv/implementations/asic/castalia/analog/data/raw/amp_op__sf__r1.csv" 1.0/(OP("/OPAMP/M4" "gds")+OP("/OPAMP/M11" "gds"))))
    errset(mtxDump("/home/mseminario2/vestarv/implementations/asic/castalia/analog/data/raw/amp_op__sf__r2.csv" 1.0/(OP("/OPAMP/M12" "gds")+OP("/OPAMP/M5" "gds"))))
  )
)

;; ---- corner 4 (sf) / test amp_stb
when(isDir("/home/mseminario2/chips/castalia/simarchive/anatop_tb_tia/tia_2026-07-28/Interactive.9/4/UnityFeedbackTB/psf")
  openResults("/home/mseminario2/chips/castalia/simarchive/anatop_tb_tia/tia_2026-07-28/Interactive.9/4/UnityFeedbackTB/psf")
  when(member('stb results())
    selectResult('stb)
    mtxP = outfile("/home/mseminario2/vestarv/implementations/asic/castalia/analog/data/raw/amp_stb__sf.meta" "w")
    fprintf(mtxP "sweep %%L\n" car(errset(sweepNames())))
    close(mtxP)
    errset(mtxDump("/home/mseminario2/vestarv/implementations/asic/castalia/analog/data/raw/amp_stb__sf__a0.csv" ymax(dB20(getData("loopGain" ?result "stb")))))
    errset(mtxDump("/home/mseminario2/vestarv/implementations/asic/castalia/analog/data/raw/amp_stb__sf__fp1_meas.csv" bandwidth(getData("loopGain" ?result "stb") 3 "low")))
    errset(mtxDump("/home/mseminario2/vestarv/implementations/asic/castalia/analog/data/raw/amp_stb__sf__gm.csv" getData("gainMargin" ?result "stb_margin")))
    errset(mtxDump("/home/mseminario2/vestarv/implementations/asic/castalia/analog/data/raw/amp_stb__sf__lg_db.csv" dB20(getData("loopGain" ?result "stb"))))
    errset(mtxDump("/home/mseminario2/vestarv/implementations/asic/castalia/analog/data/raw/amp_stb__sf__lg_ph.csv" phase(getData("loopGain" ?result "stb"))))
    errset(mtxDump("/home/mseminario2/vestarv/implementations/asic/castalia/analog/data/raw/amp_stb__sf__pm.csv" getData("phaseMargin" ?result "stb_margin")))
    errset(mtxDump("/home/mseminario2/vestarv/implementations/asic/castalia/analog/data/raw/amp_stb__sf__ugf.csv" cross(dB20(getData("loopGain" ?result "stb")) 0 1 "falling")))
  )
)

;; ---- corner 4 (sf) / test drive_dc
when(isDir("/home/mseminario2/chips/castalia/simarchive/anatop_tb_tia/tia_2026-07-28/Interactive.9/4/DriveTB/psf")
  openResults("/home/mseminario2/chips/castalia/simarchive/anatop_tb_tia/tia_2026-07-28/Interactive.9/4/DriveTB/psf")
  when(member('dc results())
    selectResult('dc)
    mtxP = outfile("/home/mseminario2/vestarv/implementations/asic/castalia/analog/data/raw/drive_dc__sf.meta" "w")
    fprintf(mtxP "sweep %%L\n" car(errset(sweepNames())))
    close(mtxP)
    errset(mtxDump("/home/mseminario2/vestarv/implementations/asic/castalia/analog/data/raw/drive_dc__sf__i_src.csv" cross(VS("/V_OutOL") 1.2375 1 "falling")))
    errset(mtxDump("/home/mseminario2/vestarv/implementations/asic/castalia/analog/data/raw/drive_dc__sf__vo.csv" VS("/V_OutOL")))
    errset(mtxDump("/home/mseminario2/vestarv/implementations/asic/castalia/analog/data/raw/drive_dc__sf__vo_snk40.csv" value(VS("/V_OutOL") -4e-05)))
    errset(mtxDump("/home/mseminario2/vestarv/implementations/asic/castalia/analog/data/raw/drive_dc__sf__vo_src40.csv" value(VS("/V_OutOL") 4e-05)))
  )
)

;; ---- corner 4 (sf) / test slew_tr
when(isDir("/home/mseminario2/chips/castalia/simarchive/anatop_tb_tia/tia_2026-07-28/Interactive.9/4/SlewOpenLoopTB/psf")
  openResults("/home/mseminario2/chips/castalia/simarchive/anatop_tb_tia/tia_2026-07-28/Interactive.9/4/SlewOpenLoopTB/psf")
  when(member('tran results())
    selectResult('tran)
    mtxP = outfile("/home/mseminario2/vestarv/implementations/asic/castalia/analog/data/raw/slew_tr__sf.meta" "w")
    fprintf(mtxP "sweep %%L\n" car(errset(sweepNames())))
    close(mtxP)
    errset(mtxDump("/home/mseminario2/vestarv/implementations/asic/castalia/analog/data/raw/slew_tr__sf__sr_n.csv" abs(ymin(deriv(VT("/V_OutOL"))))))
    errset(mtxDump("/home/mseminario2/vestarv/implementations/asic/castalia/analog/data/raw/slew_tr__sf__sr_p.csv" ymax(deriv(VT("/V_OutOL")))))
    errset(mtxDump("/home/mseminario2/vestarv/implementations/asic/castalia/analog/data/raw/slew_tr__sf__vo.csv" VT("/V_OutOL")))
  )
)

;; ---- corner 4 (sf) / test step_tr
when(isDir("/home/mseminario2/chips/castalia/simarchive/anatop_tb_tia/tia_2026-07-28/Interactive.9/4/StepUnityFeedbackTB/psf")
  openResults("/home/mseminario2/chips/castalia/simarchive/anatop_tb_tia/tia_2026-07-28/Interactive.9/4/StepUnityFeedbackTB/psf")
  when(member('tran results())
    selectResult('tran)
    mtxP = outfile("/home/mseminario2/vestarv/implementations/asic/castalia/analog/data/raw/step_tr__sf.meta" "w")
    fprintf(mtxP "sweep %%L\n" car(errset(sweepNames())))
    close(mtxP)
    errset(mtxDump("/home/mseminario2/vestarv/implementations/asic/castalia/analog/data/raw/step_tr__sf__err_1us.csv" ((value(VT("/V_OutOL") 101e-06) - value(VT("/V_OutOL") 500e-06)) * 1000.0)))
    errset(mtxDump("/home/mseminario2/vestarv/implementations/asic/castalia/analog/data/raw/step_tr__sf__ovs.csv" ((ymax(VT("/V_OutOL")) - (VAR("V_CM")+0.5)) * 100.0)))
    errset(mtxDump("/home/mseminario2/vestarv/implementations/asic/castalia/analog/data/raw/step_tr__sf__t_pk.csv" ((xmax(VT("/V_OutOL") 1) - 100e-06) * 1000000.0)))
    errset(mtxDump("/home/mseminario2/vestarv/implementations/asic/castalia/analog/data/raw/step_tr__sf__und.csv" (((VAR("V_CM")-0.5) - ymin(VT("/V_OutOL"))) * 100.0)))
    errset(mtxDump("/home/mseminario2/vestarv/implementations/asic/castalia/analog/data/raw/step_tr__sf__vo.csv" VT("/V_OutOL")))
  )
)

;; ---- corner 4 (sf) / test tia_ac
when(isDir("/home/mseminario2/chips/castalia/simarchive/anatop_tb_tia/tia_2026-07-28/Interactive.9/4/TiaFbTB/psf")
  openResults("/home/mseminario2/chips/castalia/simarchive/anatop_tb_tia/tia_2026-07-28/Interactive.9/4/TiaFbTB/psf")
  when(member('ac results())
    selectResult('ac)
    mtxP = outfile("/home/mseminario2/vestarv/implementations/asic/castalia/analog/data/raw/tia_ac__sf.meta" "w")
    fprintf(mtxP "sweep %%L\n" car(errset(sweepNames())))
    close(mtxP)
    errset(mtxDump("/home/mseminario2/vestarv/implementations/asic/castalia/analog/data/raw/tia_ac__sf__f3db.csv" bandwidth(VF("/V_OUT") 3 "low")))
    errset(mtxDump("/home/mseminario2/vestarv/implementations/asic/castalia/analog/data/raw/tia_ac__sf__f_pk.csv" xmax(mag(VF("/V_OUT")) 1)))
    errset(mtxDump("/home/mseminario2/vestarv/implementations/asic/castalia/analog/data/raw/tia_ac__sf__peak_db.csv" (ymax(dB20(VF("/V_OUT"))) - value(dB20(VF("/V_OUT")) 1))))
    errset(mtxDump("/home/mseminario2/vestarv/implementations/asic/castalia/analog/data/raw/tia_ac__sf__zin.csv" value(mag(VF("/WE")) 1)))
    errset(mtxDump("/home/mseminario2/vestarv/implementations/asic/castalia/analog/data/raw/tia_ac__sf__zt.csv" mag(VF("/V_OUT"))))
    errset(mtxDump("/home/mseminario2/vestarv/implementations/asic/castalia/analog/data/raw/tia_ac__sf__zt_dc.csv" value(mag(VF("/V_OUT")) 1)))
    errset(mtxDump("/home/mseminario2/vestarv/implementations/asic/castalia/analog/data/raw/tia_ac__sf__zt_pk.csv" ymax(mag(VF("/V_OUT")))))
  )
)

;; ---- corner 4 (sf) / test tia_dc
when(isDir("/home/mseminario2/chips/castalia/simarchive/anatop_tb_tia/tia_2026-07-28/Interactive.9/4/TiaFbTB/psf")
  openResults("/home/mseminario2/chips/castalia/simarchive/anatop_tb_tia/tia_2026-07-28/Interactive.9/4/TiaFbTB/psf")
  when(member('dc results())
    selectResult('dc)
    mtxP = outfile("/home/mseminario2/vestarv/implementations/asic/castalia/analog/data/raw/tia_dc__sf.meta" "w")
    fprintf(mtxP "sweep %%L\n" car(errset(sweepNames())))
    close(mtxP)
    errset(mtxDump("/home/mseminario2/vestarv/implementations/asic/castalia/analog/data/raw/tia_dc__sf__idd.csv" value(abs(IDC("/POWER/SRC_VDD25/PLUS")) 0)))
    errset(mtxDump("/home/mseminario2/vestarv/implementations/asic/castalia/analog/data/raw/tia_dc__sf__rt_0.csv" value(deriv(VS("/V_OUT")) 0)))
    errset(mtxDump("/home/mseminario2/vestarv/implementations/asic/castalia/analog/data/raw/tia_dc__sf__rt_2u.csv" value(deriv(VS("/V_OUT")) 2e-06)))
    errset(mtxDump("/home/mseminario2/vestarv/implementations/asic/castalia/analog/data/raw/tia_dc__sf__vout.csv" VS("/V_OUT")))
    errset(mtxDump("/home/mseminario2/vestarv/implementations/asic/castalia/analog/data/raw/tia_dc__sf__vout_hi.csv" ymax(VS("/V_OUT"))))
    errset(mtxDump("/home/mseminario2/vestarv/implementations/asic/castalia/analog/data/raw/tia_dc__sf__vout_lo.csv" ymin(VS("/V_OUT"))))
    errset(mtxDump("/home/mseminario2/vestarv/implementations/asic/castalia/analog/data/raw/tia_dc__sf__we_err.csv" (VS("/WE") - VS("/V_CM"))))
    errset(mtxDump("/home/mseminario2/vestarv/implementations/asic/castalia/analog/data/raw/tia_dc__sf__we_err_0.csv" value((VS("/WE") - VS("/V_CM")) 0)))
    errset(mtxDump("/home/mseminario2/vestarv/implementations/asic/castalia/analog/data/raw/tia_dc__sf__we_err_n2u.csv" value((VS("/WE") - VS("/V_CM")) -2e-06)))
    errset(mtxDump("/home/mseminario2/vestarv/implementations/asic/castalia/analog/data/raw/tia_dc__sf__we_err_p2u.csv" value((VS("/WE") - VS("/V_CM")) 2e-06)))
  )
)

;; ---- corner 5 (ss) / test amp_dc
when(isDir("/home/mseminario2/chips/castalia/simarchive/anatop_tb_tia/tia_2026-07-28/Interactive.9/5/UnityFeedbackTB/psf")
  openResults("/home/mseminario2/chips/castalia/simarchive/anatop_tb_tia/tia_2026-07-28/Interactive.9/5/UnityFeedbackTB/psf")
  when(member('dc results())
    selectResult('dc)
    mtxP = outfile("/home/mseminario2/vestarv/implementations/asic/castalia/analog/data/raw/amp_dc__ss.meta" "w")
    fprintf(mtxP "sweep %%L\n" car(errset(sweepNames())))
    close(mtxP)
    errset(mtxDump("/home/mseminario2/vestarv/implementations/asic/castalia/analog/data/raw/amp_dc__ss__cm_hi.csv" cross(abs(VS("/V_OutOL")-VS("/V_InP")) 0.002 1 "rising")))
    errset(mtxDump("/home/mseminario2/vestarv/implementations/asic/castalia/analog/data/raw/amp_dc__ss__cm_lo.csv" cross(abs(VS("/V_OutOL")-VS("/V_InP")) 0.002 1 "falling")))
    errset(mtxDump("/home/mseminario2/vestarv/implementations/asic/castalia/analog/data/raw/amp_dc__ss__track_err.csv" value(abs(VS("/V_OutOL")-VS("/V_InP")) 1.25)))
    errset(mtxDump("/home/mseminario2/vestarv/implementations/asic/castalia/analog/data/raw/amp_dc__ss__vos.csv" value((VS("/V_OutOL") - VS("/V_InP")) 1.25)))
  )
)

;; ---- corner 5 (ss) / test amp_noise
when(isDir("/home/mseminario2/chips/castalia/simarchive/anatop_tb_tia/tia_2026-07-28/Interactive.9/5/UnityFeedbackTB/psf")
  openResults("/home/mseminario2/chips/castalia/simarchive/anatop_tb_tia/tia_2026-07-28/Interactive.9/5/UnityFeedbackTB/psf")
  when(member('noise results())
    selectResult('noise)
    mtxP = outfile("/home/mseminario2/vestarv/implementations/asic/castalia/analog/data/raw/amp_noise__ss.meta" "w")
    fprintf(mtxP "sweep %%L\n" car(errset(sweepNames())))
    close(mtxP)
    errset(mtxDump("/home/mseminario2/vestarv/implementations/asic/castalia/analog/data/raw/amp_noise__ss__vn_10.csv" value(getData("in" ?result "noise") 10.0)))
    errset(mtxDump("/home/mseminario2/vestarv/implementations/asic/castalia/analog/data/raw/amp_noise__ss__vn_100.csv" value(getData("in" ?result "noise") 100.0)))
    errset(mtxDump("/home/mseminario2/vestarv/implementations/asic/castalia/analog/data/raw/amp_noise__ss__vn_1k.csv" value(getData("in" ?result "noise") 1000.0)))
    errset(mtxDump("/home/mseminario2/vestarv/implementations/asic/castalia/analog/data/raw/amp_noise__ss__vn_int.csv" sqrt(integ(getData("in" ?result "noise")**2 0.1 1700.0))))
  )
)

;; ---- corner 5 (ss) / test amp_op
when(isDir("/home/mseminario2/chips/castalia/simarchive/anatop_tb_tia/tia_2026-07-28/Interactive.9/5/UnityFeedbackTB/psf")
  openResults("/home/mseminario2/chips/castalia/simarchive/anatop_tb_tia/tia_2026-07-28/Interactive.9/5/UnityFeedbackTB/psf")
  when(member('dcOpInfo results())
    selectResult('dcOpInfo)
    mtxP = outfile("/home/mseminario2/vestarv/implementations/asic/castalia/analog/data/raw/amp_op__ss.meta" "w")
    fprintf(mtxP "sweep %%L\n" car(errset(sweepNames())))
    close(mtxP)
    errset(mtxDump("/home/mseminario2/vestarv/implementations/asic/castalia/analog/data/raw/amp_op__ss__a0_pred.csv" dB20((OP("/OPAMP/M4" "gm")/(OP("/OPAMP/M4" "gds")+OP("/OPAMP/M11" "gds")))*(OP("/OPAMP/M12" "gm")/(OP("/OPAMP/M12" "gds")+OP("/OPAMP/M5" "gds"))))))
    errset(mtxDump("/home/mseminario2/vestarv/implementations/asic/castalia/analog/data/raw/amp_op__ss__cc.csv" OP("/OPAMP/C0" "cap")))
    errset(mtxDump("/home/mseminario2/vestarv/implementations/asic/castalia/analog/data/raw/amp_op__ss__fp1_pred.csv" 1.0/(2*3.14159265358979*(1.0/(OP("/OPAMP/M4" "gds")+OP("/OPAMP/M11" "gds")))*(OP("/OPAMP/M12" "gm")/(OP("/OPAMP/M12" "gds")+OP("/OPAMP/M5" "gds")))*OP("/OPAMP/C0" "cap"))))
    errset(mtxDump("/home/mseminario2/vestarv/implementations/asic/castalia/analog/data/raw/amp_op__ss__fp2_pred.csv" OP("/OPAMP/M12" "gm")/(2*3.14159265358979*VAR("C_L"))))
    errset(mtxDump("/home/mseminario2/vestarv/implementations/asic/castalia/analog/data/raw/amp_op__ss__fu_pred.csv" OP("/OPAMP/M4" "gm")/(2*3.14159265358979*OP("/OPAMP/C0" "cap"))))
    errset(mtxDump("/home/mseminario2/vestarv/implementations/asic/castalia/analog/data/raw/amp_op__ss__gm1.csv" OP("/OPAMP/M4" "gm")))
    errset(mtxDump("/home/mseminario2/vestarv/implementations/asic/castalia/analog/data/raw/amp_op__ss__gm2.csv" OP("/OPAMP/M12" "gm")))
    errset(mtxDump("/home/mseminario2/vestarv/implementations/asic/castalia/analog/data/raw/amp_op__ss__itail.csv" abs(OP("/OPAMP/M2" "id"))))
    errset(mtxDump("/home/mseminario2/vestarv/implementations/asic/castalia/analog/data/raw/amp_op__ss__r1.csv" 1.0/(OP("/OPAMP/M4" "gds")+OP("/OPAMP/M11" "gds"))))
    errset(mtxDump("/home/mseminario2/vestarv/implementations/asic/castalia/analog/data/raw/amp_op__ss__r2.csv" 1.0/(OP("/OPAMP/M12" "gds")+OP("/OPAMP/M5" "gds"))))
  )
)

;; ---- corner 5 (ss) / test amp_stb
when(isDir("/home/mseminario2/chips/castalia/simarchive/anatop_tb_tia/tia_2026-07-28/Interactive.9/5/UnityFeedbackTB/psf")
  openResults("/home/mseminario2/chips/castalia/simarchive/anatop_tb_tia/tia_2026-07-28/Interactive.9/5/UnityFeedbackTB/psf")
  when(member('stb results())
    selectResult('stb)
    mtxP = outfile("/home/mseminario2/vestarv/implementations/asic/castalia/analog/data/raw/amp_stb__ss.meta" "w")
    fprintf(mtxP "sweep %%L\n" car(errset(sweepNames())))
    close(mtxP)
    errset(mtxDump("/home/mseminario2/vestarv/implementations/asic/castalia/analog/data/raw/amp_stb__ss__a0.csv" ymax(dB20(getData("loopGain" ?result "stb")))))
    errset(mtxDump("/home/mseminario2/vestarv/implementations/asic/castalia/analog/data/raw/amp_stb__ss__fp1_meas.csv" bandwidth(getData("loopGain" ?result "stb") 3 "low")))
    errset(mtxDump("/home/mseminario2/vestarv/implementations/asic/castalia/analog/data/raw/amp_stb__ss__gm.csv" getData("gainMargin" ?result "stb_margin")))
    errset(mtxDump("/home/mseminario2/vestarv/implementations/asic/castalia/analog/data/raw/amp_stb__ss__lg_db.csv" dB20(getData("loopGain" ?result "stb"))))
    errset(mtxDump("/home/mseminario2/vestarv/implementations/asic/castalia/analog/data/raw/amp_stb__ss__lg_ph.csv" phase(getData("loopGain" ?result "stb"))))
    errset(mtxDump("/home/mseminario2/vestarv/implementations/asic/castalia/analog/data/raw/amp_stb__ss__pm.csv" getData("phaseMargin" ?result "stb_margin")))
    errset(mtxDump("/home/mseminario2/vestarv/implementations/asic/castalia/analog/data/raw/amp_stb__ss__ugf.csv" cross(dB20(getData("loopGain" ?result "stb")) 0 1 "falling")))
  )
)

;; ---- corner 5 (ss) / test drive_dc
when(isDir("/home/mseminario2/chips/castalia/simarchive/anatop_tb_tia/tia_2026-07-28/Interactive.9/5/DriveTB/psf")
  openResults("/home/mseminario2/chips/castalia/simarchive/anatop_tb_tia/tia_2026-07-28/Interactive.9/5/DriveTB/psf")
  when(member('dc results())
    selectResult('dc)
    mtxP = outfile("/home/mseminario2/vestarv/implementations/asic/castalia/analog/data/raw/drive_dc__ss.meta" "w")
    fprintf(mtxP "sweep %%L\n" car(errset(sweepNames())))
    close(mtxP)
    errset(mtxDump("/home/mseminario2/vestarv/implementations/asic/castalia/analog/data/raw/drive_dc__ss__i_src.csv" cross(VS("/V_OutOL") 1.2375 1 "falling")))
    errset(mtxDump("/home/mseminario2/vestarv/implementations/asic/castalia/analog/data/raw/drive_dc__ss__vo.csv" VS("/V_OutOL")))
    errset(mtxDump("/home/mseminario2/vestarv/implementations/asic/castalia/analog/data/raw/drive_dc__ss__vo_snk40.csv" value(VS("/V_OutOL") -4e-05)))
    errset(mtxDump("/home/mseminario2/vestarv/implementations/asic/castalia/analog/data/raw/drive_dc__ss__vo_src40.csv" value(VS("/V_OutOL") 4e-05)))
  )
)

;; ---- corner 5 (ss) / test slew_tr
when(isDir("/home/mseminario2/chips/castalia/simarchive/anatop_tb_tia/tia_2026-07-28/Interactive.9/5/SlewOpenLoopTB/psf")
  openResults("/home/mseminario2/chips/castalia/simarchive/anatop_tb_tia/tia_2026-07-28/Interactive.9/5/SlewOpenLoopTB/psf")
  when(member('tran results())
    selectResult('tran)
    mtxP = outfile("/home/mseminario2/vestarv/implementations/asic/castalia/analog/data/raw/slew_tr__ss.meta" "w")
    fprintf(mtxP "sweep %%L\n" car(errset(sweepNames())))
    close(mtxP)
    errset(mtxDump("/home/mseminario2/vestarv/implementations/asic/castalia/analog/data/raw/slew_tr__ss__sr_n.csv" abs(ymin(deriv(VT("/V_OutOL"))))))
    errset(mtxDump("/home/mseminario2/vestarv/implementations/asic/castalia/analog/data/raw/slew_tr__ss__sr_p.csv" ymax(deriv(VT("/V_OutOL")))))
    errset(mtxDump("/home/mseminario2/vestarv/implementations/asic/castalia/analog/data/raw/slew_tr__ss__vo.csv" VT("/V_OutOL")))
  )
)

;; ---- corner 5 (ss) / test step_tr
when(isDir("/home/mseminario2/chips/castalia/simarchive/anatop_tb_tia/tia_2026-07-28/Interactive.9/5/StepUnityFeedbackTB/psf")
  openResults("/home/mseminario2/chips/castalia/simarchive/anatop_tb_tia/tia_2026-07-28/Interactive.9/5/StepUnityFeedbackTB/psf")
  when(member('tran results())
    selectResult('tran)
    mtxP = outfile("/home/mseminario2/vestarv/implementations/asic/castalia/analog/data/raw/step_tr__ss.meta" "w")
    fprintf(mtxP "sweep %%L\n" car(errset(sweepNames())))
    close(mtxP)
    errset(mtxDump("/home/mseminario2/vestarv/implementations/asic/castalia/analog/data/raw/step_tr__ss__err_1us.csv" ((value(VT("/V_OutOL") 101e-06) - value(VT("/V_OutOL") 500e-06)) * 1000.0)))
    errset(mtxDump("/home/mseminario2/vestarv/implementations/asic/castalia/analog/data/raw/step_tr__ss__ovs.csv" ((ymax(VT("/V_OutOL")) - (VAR("V_CM")+0.5)) * 100.0)))
    errset(mtxDump("/home/mseminario2/vestarv/implementations/asic/castalia/analog/data/raw/step_tr__ss__t_pk.csv" ((xmax(VT("/V_OutOL") 1) - 100e-06) * 1000000.0)))
    errset(mtxDump("/home/mseminario2/vestarv/implementations/asic/castalia/analog/data/raw/step_tr__ss__und.csv" (((VAR("V_CM")-0.5) - ymin(VT("/V_OutOL"))) * 100.0)))
    errset(mtxDump("/home/mseminario2/vestarv/implementations/asic/castalia/analog/data/raw/step_tr__ss__vo.csv" VT("/V_OutOL")))
  )
)

;; ---- corner 5 (ss) / test tia_ac
when(isDir("/home/mseminario2/chips/castalia/simarchive/anatop_tb_tia/tia_2026-07-28/Interactive.9/5/TiaFbTB/psf")
  openResults("/home/mseminario2/chips/castalia/simarchive/anatop_tb_tia/tia_2026-07-28/Interactive.9/5/TiaFbTB/psf")
  when(member('ac results())
    selectResult('ac)
    mtxP = outfile("/home/mseminario2/vestarv/implementations/asic/castalia/analog/data/raw/tia_ac__ss.meta" "w")
    fprintf(mtxP "sweep %%L\n" car(errset(sweepNames())))
    close(mtxP)
    errset(mtxDump("/home/mseminario2/vestarv/implementations/asic/castalia/analog/data/raw/tia_ac__ss__f3db.csv" bandwidth(VF("/V_OUT") 3 "low")))
    errset(mtxDump("/home/mseminario2/vestarv/implementations/asic/castalia/analog/data/raw/tia_ac__ss__f_pk.csv" xmax(mag(VF("/V_OUT")) 1)))
    errset(mtxDump("/home/mseminario2/vestarv/implementations/asic/castalia/analog/data/raw/tia_ac__ss__peak_db.csv" (ymax(dB20(VF("/V_OUT"))) - value(dB20(VF("/V_OUT")) 1))))
    errset(mtxDump("/home/mseminario2/vestarv/implementations/asic/castalia/analog/data/raw/tia_ac__ss__zin.csv" value(mag(VF("/WE")) 1)))
    errset(mtxDump("/home/mseminario2/vestarv/implementations/asic/castalia/analog/data/raw/tia_ac__ss__zt.csv" mag(VF("/V_OUT"))))
    errset(mtxDump("/home/mseminario2/vestarv/implementations/asic/castalia/analog/data/raw/tia_ac__ss__zt_dc.csv" value(mag(VF("/V_OUT")) 1)))
    errset(mtxDump("/home/mseminario2/vestarv/implementations/asic/castalia/analog/data/raw/tia_ac__ss__zt_pk.csv" ymax(mag(VF("/V_OUT")))))
  )
)

;; ---- corner 5 (ss) / test tia_dc
when(isDir("/home/mseminario2/chips/castalia/simarchive/anatop_tb_tia/tia_2026-07-28/Interactive.9/5/TiaFbTB/psf")
  openResults("/home/mseminario2/chips/castalia/simarchive/anatop_tb_tia/tia_2026-07-28/Interactive.9/5/TiaFbTB/psf")
  when(member('dc results())
    selectResult('dc)
    mtxP = outfile("/home/mseminario2/vestarv/implementations/asic/castalia/analog/data/raw/tia_dc__ss.meta" "w")
    fprintf(mtxP "sweep %%L\n" car(errset(sweepNames())))
    close(mtxP)
    errset(mtxDump("/home/mseminario2/vestarv/implementations/asic/castalia/analog/data/raw/tia_dc__ss__idd.csv" value(abs(IDC("/POWER/SRC_VDD25/PLUS")) 0)))
    errset(mtxDump("/home/mseminario2/vestarv/implementations/asic/castalia/analog/data/raw/tia_dc__ss__rt_0.csv" value(deriv(VS("/V_OUT")) 0)))
    errset(mtxDump("/home/mseminario2/vestarv/implementations/asic/castalia/analog/data/raw/tia_dc__ss__rt_2u.csv" value(deriv(VS("/V_OUT")) 2e-06)))
    errset(mtxDump("/home/mseminario2/vestarv/implementations/asic/castalia/analog/data/raw/tia_dc__ss__vout.csv" VS("/V_OUT")))
    errset(mtxDump("/home/mseminario2/vestarv/implementations/asic/castalia/analog/data/raw/tia_dc__ss__vout_hi.csv" ymax(VS("/V_OUT"))))
    errset(mtxDump("/home/mseminario2/vestarv/implementations/asic/castalia/analog/data/raw/tia_dc__ss__vout_lo.csv" ymin(VS("/V_OUT"))))
    errset(mtxDump("/home/mseminario2/vestarv/implementations/asic/castalia/analog/data/raw/tia_dc__ss__we_err.csv" (VS("/WE") - VS("/V_CM"))))
    errset(mtxDump("/home/mseminario2/vestarv/implementations/asic/castalia/analog/data/raw/tia_dc__ss__we_err_0.csv" value((VS("/WE") - VS("/V_CM")) 0)))
    errset(mtxDump("/home/mseminario2/vestarv/implementations/asic/castalia/analog/data/raw/tia_dc__ss__we_err_n2u.csv" value((VS("/WE") - VS("/V_CM")) -2e-06)))
    errset(mtxDump("/home/mseminario2/vestarv/implementations/asic/castalia/analog/data/raw/tia_dc__ss__we_err_p2u.csv" value((VS("/WE") - VS("/V_CM")) 2e-06)))
  )
)

printf("MTX_EXTRACT_DONE\n")
exit(0)
