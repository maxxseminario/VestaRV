;; generated by maestro2tex -- do not edit
procedure(mtxDump(fname wv)
  let((xs ys n p)
    p = outfile(fname "w")
    cond(
      (null(wv) fprintf(p "#nil\n"))
      (drIsWaveform(wv)
        xs = drGetWaveformXVec(wv)
        ys = drGetWaveformYVec(wv)
        n = drVectorLength(xs)
        for(i 0 n-1
          fprintf(p "%.10g %.10g\n" drGetElem(xs i) drGetElem(ys i)))
      )
      (t fprintf(p "#scalar %.10g\n" float(wv)))
    )
    close(p)
    t))

;; ---- corner 1 (ff1) / test drive_map
when(isDir("/home/mseminario2/chips/castalia/ic/.simulation/castalia/anatop_tb_controlamp/maestro/results/maestro/Interactive.131/1/DriveMapTB/psf")
  openResults("/home/mseminario2/chips/castalia/ic/.simulation/castalia/anatop_tb_controlamp/maestro/results/maestro/Interactive.131/1/DriveMapTB/psf")
  when(member('dc results())
    selectResult('dc)
    mtxP = outfile("/home/mseminario2/vestarv/implementations/asic/castalia/analog/data/raw/drive_map__ff1.meta" "w")
    fprintf(mtxP "sweep %%L\n" car(errset(sweepNames())))
    close(mtxP)
    errset(mtxDump("/home/mseminario2/vestarv/implementations/asic/castalia/analog/data/raw/drive_map__ff1__i_sink.csv" cross((v("/V_OutOL")-v("/V_InP")) 0.05 1 "falling")))
    errset(mtxDump("/home/mseminario2/vestarv/implementations/asic/castalia/analog/data/raw/drive_map__ff1__i_span.csv" (cross((v("/V_OutOL")-v("/V_InP")) -0.05 1 "falling")-cross((v("/V_OutOL")-v("/V_InP")) 0.05 1 "falling"))))
    errset(mtxDump("/home/mseminario2/vestarv/implementations/asic/castalia/analog/data/raw/drive_map__ff1__i_src.csv" cross((v("/V_OutOL")-v("/V_InP")) -0.05 1 "falling")))
    errset(mtxDump("/home/mseminario2/vestarv/implementations/asic/castalia/analog/data/raw/drive_map__ff1__idd_q.csv" value(abs(i("/POWER/SRC_VDD25/PLUS")) 0.0)))
    errset(mtxDump("/home/mseminario2/vestarv/implementations/asic/castalia/analog/data/raw/drive_map__ff1__rout.csv" abs((value(v("/V_OutOL") 0.5e-6)-value(v("/V_OutOL") -0.5e-6))/1e-6)))
    errset(mtxDump("/home/mseminario2/vestarv/implementations/asic/castalia/analog/data/raw/drive_map__ff1__verr.csv" (v("/V_OutOL")-v("/V_InP"))))
    errset(mtxDump("/home/mseminario2/vestarv/implementations/asic/castalia/analog/data/raw/drive_map__ff1__verr_q.csv" value((v("/V_OutOL")-v("/V_InP")) 0.0)))
  )
)

;; ---- corner 2 (ff2) / test drive_map
when(isDir("/home/mseminario2/chips/castalia/ic/.simulation/castalia/anatop_tb_controlamp/maestro/results/maestro/Interactive.131/2/DriveMapTB/psf")
  openResults("/home/mseminario2/chips/castalia/ic/.simulation/castalia/anatop_tb_controlamp/maestro/results/maestro/Interactive.131/2/DriveMapTB/psf")
  when(member('dc results())
    selectResult('dc)
    mtxP = outfile("/home/mseminario2/vestarv/implementations/asic/castalia/analog/data/raw/drive_map__ff2.meta" "w")
    fprintf(mtxP "sweep %%L\n" car(errset(sweepNames())))
    close(mtxP)
    errset(mtxDump("/home/mseminario2/vestarv/implementations/asic/castalia/analog/data/raw/drive_map__ff2__i_sink.csv" cross((v("/V_OutOL")-v("/V_InP")) 0.05 1 "falling")))
    errset(mtxDump("/home/mseminario2/vestarv/implementations/asic/castalia/analog/data/raw/drive_map__ff2__i_span.csv" (cross((v("/V_OutOL")-v("/V_InP")) -0.05 1 "falling")-cross((v("/V_OutOL")-v("/V_InP")) 0.05 1 "falling"))))
    errset(mtxDump("/home/mseminario2/vestarv/implementations/asic/castalia/analog/data/raw/drive_map__ff2__i_src.csv" cross((v("/V_OutOL")-v("/V_InP")) -0.05 1 "falling")))
    errset(mtxDump("/home/mseminario2/vestarv/implementations/asic/castalia/analog/data/raw/drive_map__ff2__idd_q.csv" value(abs(i("/POWER/SRC_VDD25/PLUS")) 0.0)))
    errset(mtxDump("/home/mseminario2/vestarv/implementations/asic/castalia/analog/data/raw/drive_map__ff2__rout.csv" abs((value(v("/V_OutOL") 0.5e-6)-value(v("/V_OutOL") -0.5e-6))/1e-6)))
    errset(mtxDump("/home/mseminario2/vestarv/implementations/asic/castalia/analog/data/raw/drive_map__ff2__verr.csv" (v("/V_OutOL")-v("/V_InP"))))
    errset(mtxDump("/home/mseminario2/vestarv/implementations/asic/castalia/analog/data/raw/drive_map__ff2__verr_q.csv" value((v("/V_OutOL")-v("/V_InP")) 0.0)))
  )
)

;; ---- corner 3 (ff3) / test drive_map
when(isDir("/home/mseminario2/chips/castalia/ic/.simulation/castalia/anatop_tb_controlamp/maestro/results/maestro/Interactive.131/3/DriveMapTB/psf")
  openResults("/home/mseminario2/chips/castalia/ic/.simulation/castalia/anatop_tb_controlamp/maestro/results/maestro/Interactive.131/3/DriveMapTB/psf")
  when(member('dc results())
    selectResult('dc)
    mtxP = outfile("/home/mseminario2/vestarv/implementations/asic/castalia/analog/data/raw/drive_map__ff3.meta" "w")
    fprintf(mtxP "sweep %%L\n" car(errset(sweepNames())))
    close(mtxP)
    errset(mtxDump("/home/mseminario2/vestarv/implementations/asic/castalia/analog/data/raw/drive_map__ff3__i_sink.csv" cross((v("/V_OutOL")-v("/V_InP")) 0.05 1 "falling")))
    errset(mtxDump("/home/mseminario2/vestarv/implementations/asic/castalia/analog/data/raw/drive_map__ff3__i_span.csv" (cross((v("/V_OutOL")-v("/V_InP")) -0.05 1 "falling")-cross((v("/V_OutOL")-v("/V_InP")) 0.05 1 "falling"))))
    errset(mtxDump("/home/mseminario2/vestarv/implementations/asic/castalia/analog/data/raw/drive_map__ff3__i_src.csv" cross((v("/V_OutOL")-v("/V_InP")) -0.05 1 "falling")))
    errset(mtxDump("/home/mseminario2/vestarv/implementations/asic/castalia/analog/data/raw/drive_map__ff3__idd_q.csv" value(abs(i("/POWER/SRC_VDD25/PLUS")) 0.0)))
    errset(mtxDump("/home/mseminario2/vestarv/implementations/asic/castalia/analog/data/raw/drive_map__ff3__rout.csv" abs((value(v("/V_OutOL") 0.5e-6)-value(v("/V_OutOL") -0.5e-6))/1e-6)))
    errset(mtxDump("/home/mseminario2/vestarv/implementations/asic/castalia/analog/data/raw/drive_map__ff3__verr.csv" (v("/V_OutOL")-v("/V_InP"))))
    errset(mtxDump("/home/mseminario2/vestarv/implementations/asic/castalia/analog/data/raw/drive_map__ff3__verr_q.csv" value((v("/V_OutOL")-v("/V_InP")) 0.0)))
  )
)

;; ---- corner 4 (ff4) / test drive_map
when(isDir("/home/mseminario2/chips/castalia/ic/.simulation/castalia/anatop_tb_controlamp/maestro/results/maestro/Interactive.131/4/DriveMapTB/psf")
  openResults("/home/mseminario2/chips/castalia/ic/.simulation/castalia/anatop_tb_controlamp/maestro/results/maestro/Interactive.131/4/DriveMapTB/psf")
  when(member('dc results())
    selectResult('dc)
    mtxP = outfile("/home/mseminario2/vestarv/implementations/asic/castalia/analog/data/raw/drive_map__ff4.meta" "w")
    fprintf(mtxP "sweep %%L\n" car(errset(sweepNames())))
    close(mtxP)
    errset(mtxDump("/home/mseminario2/vestarv/implementations/asic/castalia/analog/data/raw/drive_map__ff4__i_sink.csv" cross((v("/V_OutOL")-v("/V_InP")) 0.05 1 "falling")))
    errset(mtxDump("/home/mseminario2/vestarv/implementations/asic/castalia/analog/data/raw/drive_map__ff4__i_span.csv" (cross((v("/V_OutOL")-v("/V_InP")) -0.05 1 "falling")-cross((v("/V_OutOL")-v("/V_InP")) 0.05 1 "falling"))))
    errset(mtxDump("/home/mseminario2/vestarv/implementations/asic/castalia/analog/data/raw/drive_map__ff4__i_src.csv" cross((v("/V_OutOL")-v("/V_InP")) -0.05 1 "falling")))
    errset(mtxDump("/home/mseminario2/vestarv/implementations/asic/castalia/analog/data/raw/drive_map__ff4__idd_q.csv" value(abs(i("/POWER/SRC_VDD25/PLUS")) 0.0)))
    errset(mtxDump("/home/mseminario2/vestarv/implementations/asic/castalia/analog/data/raw/drive_map__ff4__rout.csv" abs((value(v("/V_OutOL") 0.5e-6)-value(v("/V_OutOL") -0.5e-6))/1e-6)))
    errset(mtxDump("/home/mseminario2/vestarv/implementations/asic/castalia/analog/data/raw/drive_map__ff4__verr.csv" (v("/V_OutOL")-v("/V_InP"))))
    errset(mtxDump("/home/mseminario2/vestarv/implementations/asic/castalia/analog/data/raw/drive_map__ff4__verr_q.csv" value((v("/V_OutOL")-v("/V_InP")) 0.0)))
  )
)

;; ---- corner 5 (ff5) / test drive_map
when(isDir("/home/mseminario2/chips/castalia/ic/.simulation/castalia/anatop_tb_controlamp/maestro/results/maestro/Interactive.131/5/DriveMapTB/psf")
  openResults("/home/mseminario2/chips/castalia/ic/.simulation/castalia/anatop_tb_controlamp/maestro/results/maestro/Interactive.131/5/DriveMapTB/psf")
  when(member('dc results())
    selectResult('dc)
    mtxP = outfile("/home/mseminario2/vestarv/implementations/asic/castalia/analog/data/raw/drive_map__ff5.meta" "w")
    fprintf(mtxP "sweep %%L\n" car(errset(sweepNames())))
    close(mtxP)
    errset(mtxDump("/home/mseminario2/vestarv/implementations/asic/castalia/analog/data/raw/drive_map__ff5__i_sink.csv" cross((v("/V_OutOL")-v("/V_InP")) 0.05 1 "falling")))
    errset(mtxDump("/home/mseminario2/vestarv/implementations/asic/castalia/analog/data/raw/drive_map__ff5__i_span.csv" (cross((v("/V_OutOL")-v("/V_InP")) -0.05 1 "falling")-cross((v("/V_OutOL")-v("/V_InP")) 0.05 1 "falling"))))
    errset(mtxDump("/home/mseminario2/vestarv/implementations/asic/castalia/analog/data/raw/drive_map__ff5__i_src.csv" cross((v("/V_OutOL")-v("/V_InP")) -0.05 1 "falling")))
    errset(mtxDump("/home/mseminario2/vestarv/implementations/asic/castalia/analog/data/raw/drive_map__ff5__idd_q.csv" value(abs(i("/POWER/SRC_VDD25/PLUS")) 0.0)))
    errset(mtxDump("/home/mseminario2/vestarv/implementations/asic/castalia/analog/data/raw/drive_map__ff5__rout.csv" abs((value(v("/V_OutOL") 0.5e-6)-value(v("/V_OutOL") -0.5e-6))/1e-6)))
    errset(mtxDump("/home/mseminario2/vestarv/implementations/asic/castalia/analog/data/raw/drive_map__ff5__verr.csv" (v("/V_OutOL")-v("/V_InP"))))
    errset(mtxDump("/home/mseminario2/vestarv/implementations/asic/castalia/analog/data/raw/drive_map__ff5__verr_q.csv" value((v("/V_OutOL")-v("/V_InP")) 0.0)))
  )
)

;; ---- corner 6 (ff6) / test drive_map
when(isDir("/home/mseminario2/chips/castalia/ic/.simulation/castalia/anatop_tb_controlamp/maestro/results/maestro/Interactive.131/6/DriveMapTB/psf")
  openResults("/home/mseminario2/chips/castalia/ic/.simulation/castalia/anatop_tb_controlamp/maestro/results/maestro/Interactive.131/6/DriveMapTB/psf")
  when(member('dc results())
    selectResult('dc)
    mtxP = outfile("/home/mseminario2/vestarv/implementations/asic/castalia/analog/data/raw/drive_map__ff6.meta" "w")
    fprintf(mtxP "sweep %%L\n" car(errset(sweepNames())))
    close(mtxP)
    errset(mtxDump("/home/mseminario2/vestarv/implementations/asic/castalia/analog/data/raw/drive_map__ff6__i_sink.csv" cross((v("/V_OutOL")-v("/V_InP")) 0.05 1 "falling")))
    errset(mtxDump("/home/mseminario2/vestarv/implementations/asic/castalia/analog/data/raw/drive_map__ff6__i_span.csv" (cross((v("/V_OutOL")-v("/V_InP")) -0.05 1 "falling")-cross((v("/V_OutOL")-v("/V_InP")) 0.05 1 "falling"))))
    errset(mtxDump("/home/mseminario2/vestarv/implementations/asic/castalia/analog/data/raw/drive_map__ff6__i_src.csv" cross((v("/V_OutOL")-v("/V_InP")) -0.05 1 "falling")))
    errset(mtxDump("/home/mseminario2/vestarv/implementations/asic/castalia/analog/data/raw/drive_map__ff6__idd_q.csv" value(abs(i("/POWER/SRC_VDD25/PLUS")) 0.0)))
    errset(mtxDump("/home/mseminario2/vestarv/implementations/asic/castalia/analog/data/raw/drive_map__ff6__rout.csv" abs((value(v("/V_OutOL") 0.5e-6)-value(v("/V_OutOL") -0.5e-6))/1e-6)))
    errset(mtxDump("/home/mseminario2/vestarv/implementations/asic/castalia/analog/data/raw/drive_map__ff6__verr.csv" (v("/V_OutOL")-v("/V_InP"))))
    errset(mtxDump("/home/mseminario2/vestarv/implementations/asic/castalia/analog/data/raw/drive_map__ff6__verr_q.csv" value((v("/V_OutOL")-v("/V_InP")) 0.0)))
  )
)

;; ---- corner 7 (ff7) / test drive_map
when(isDir("/home/mseminario2/chips/castalia/ic/.simulation/castalia/anatop_tb_controlamp/maestro/results/maestro/Interactive.131/7/DriveMapTB/psf")
  openResults("/home/mseminario2/chips/castalia/ic/.simulation/castalia/anatop_tb_controlamp/maestro/results/maestro/Interactive.131/7/DriveMapTB/psf")
  when(member('dc results())
    selectResult('dc)
    mtxP = outfile("/home/mseminario2/vestarv/implementations/asic/castalia/analog/data/raw/drive_map__ff7.meta" "w")
    fprintf(mtxP "sweep %%L\n" car(errset(sweepNames())))
    close(mtxP)
    errset(mtxDump("/home/mseminario2/vestarv/implementations/asic/castalia/analog/data/raw/drive_map__ff7__i_sink.csv" cross((v("/V_OutOL")-v("/V_InP")) 0.05 1 "falling")))
    errset(mtxDump("/home/mseminario2/vestarv/implementations/asic/castalia/analog/data/raw/drive_map__ff7__i_span.csv" (cross((v("/V_OutOL")-v("/V_InP")) -0.05 1 "falling")-cross((v("/V_OutOL")-v("/V_InP")) 0.05 1 "falling"))))
    errset(mtxDump("/home/mseminario2/vestarv/implementations/asic/castalia/analog/data/raw/drive_map__ff7__i_src.csv" cross((v("/V_OutOL")-v("/V_InP")) -0.05 1 "falling")))
    errset(mtxDump("/home/mseminario2/vestarv/implementations/asic/castalia/analog/data/raw/drive_map__ff7__idd_q.csv" value(abs(i("/POWER/SRC_VDD25/PLUS")) 0.0)))
    errset(mtxDump("/home/mseminario2/vestarv/implementations/asic/castalia/analog/data/raw/drive_map__ff7__rout.csv" abs((value(v("/V_OutOL") 0.5e-6)-value(v("/V_OutOL") -0.5e-6))/1e-6)))
    errset(mtxDump("/home/mseminario2/vestarv/implementations/asic/castalia/analog/data/raw/drive_map__ff7__verr.csv" (v("/V_OutOL")-v("/V_InP"))))
    errset(mtxDump("/home/mseminario2/vestarv/implementations/asic/castalia/analog/data/raw/drive_map__ff7__verr_q.csv" value((v("/V_OutOL")-v("/V_InP")) 0.0)))
  )
)

;; ---- corner 8 (ff8) / test drive_map
when(isDir("/home/mseminario2/chips/castalia/ic/.simulation/castalia/anatop_tb_controlamp/maestro/results/maestro/Interactive.131/8/DriveMapTB/psf")
  openResults("/home/mseminario2/chips/castalia/ic/.simulation/castalia/anatop_tb_controlamp/maestro/results/maestro/Interactive.131/8/DriveMapTB/psf")
  when(member('dc results())
    selectResult('dc)
    mtxP = outfile("/home/mseminario2/vestarv/implementations/asic/castalia/analog/data/raw/drive_map__ff8.meta" "w")
    fprintf(mtxP "sweep %%L\n" car(errset(sweepNames())))
    close(mtxP)
    errset(mtxDump("/home/mseminario2/vestarv/implementations/asic/castalia/analog/data/raw/drive_map__ff8__i_sink.csv" cross((v("/V_OutOL")-v("/V_InP")) 0.05 1 "falling")))
    errset(mtxDump("/home/mseminario2/vestarv/implementations/asic/castalia/analog/data/raw/drive_map__ff8__i_span.csv" (cross((v("/V_OutOL")-v("/V_InP")) -0.05 1 "falling")-cross((v("/V_OutOL")-v("/V_InP")) 0.05 1 "falling"))))
    errset(mtxDump("/home/mseminario2/vestarv/implementations/asic/castalia/analog/data/raw/drive_map__ff8__i_src.csv" cross((v("/V_OutOL")-v("/V_InP")) -0.05 1 "falling")))
    errset(mtxDump("/home/mseminario2/vestarv/implementations/asic/castalia/analog/data/raw/drive_map__ff8__idd_q.csv" value(abs(i("/POWER/SRC_VDD25/PLUS")) 0.0)))
    errset(mtxDump("/home/mseminario2/vestarv/implementations/asic/castalia/analog/data/raw/drive_map__ff8__rout.csv" abs((value(v("/V_OutOL") 0.5e-6)-value(v("/V_OutOL") -0.5e-6))/1e-6)))
    errset(mtxDump("/home/mseminario2/vestarv/implementations/asic/castalia/analog/data/raw/drive_map__ff8__verr.csv" (v("/V_OutOL")-v("/V_InP"))))
    errset(mtxDump("/home/mseminario2/vestarv/implementations/asic/castalia/analog/data/raw/drive_map__ff8__verr_q.csv" value((v("/V_OutOL")-v("/V_InP")) 0.0)))
  )
)

;; ---- corner 9 (ff9) / test drive_map
when(isDir("/home/mseminario2/chips/castalia/ic/.simulation/castalia/anatop_tb_controlamp/maestro/results/maestro/Interactive.131/9/DriveMapTB/psf")
  openResults("/home/mseminario2/chips/castalia/ic/.simulation/castalia/anatop_tb_controlamp/maestro/results/maestro/Interactive.131/9/DriveMapTB/psf")
  when(member('dc results())
    selectResult('dc)
    mtxP = outfile("/home/mseminario2/vestarv/implementations/asic/castalia/analog/data/raw/drive_map__ff9.meta" "w")
    fprintf(mtxP "sweep %%L\n" car(errset(sweepNames())))
    close(mtxP)
    errset(mtxDump("/home/mseminario2/vestarv/implementations/asic/castalia/analog/data/raw/drive_map__ff9__i_sink.csv" cross((v("/V_OutOL")-v("/V_InP")) 0.05 1 "falling")))
    errset(mtxDump("/home/mseminario2/vestarv/implementations/asic/castalia/analog/data/raw/drive_map__ff9__i_span.csv" (cross((v("/V_OutOL")-v("/V_InP")) -0.05 1 "falling")-cross((v("/V_OutOL")-v("/V_InP")) 0.05 1 "falling"))))
    errset(mtxDump("/home/mseminario2/vestarv/implementations/asic/castalia/analog/data/raw/drive_map__ff9__i_src.csv" cross((v("/V_OutOL")-v("/V_InP")) -0.05 1 "falling")))
    errset(mtxDump("/home/mseminario2/vestarv/implementations/asic/castalia/analog/data/raw/drive_map__ff9__idd_q.csv" value(abs(i("/POWER/SRC_VDD25/PLUS")) 0.0)))
    errset(mtxDump("/home/mseminario2/vestarv/implementations/asic/castalia/analog/data/raw/drive_map__ff9__rout.csv" abs((value(v("/V_OutOL") 0.5e-6)-value(v("/V_OutOL") -0.5e-6))/1e-6)))
    errset(mtxDump("/home/mseminario2/vestarv/implementations/asic/castalia/analog/data/raw/drive_map__ff9__verr.csv" (v("/V_OutOL")-v("/V_InP"))))
    errset(mtxDump("/home/mseminario2/vestarv/implementations/asic/castalia/analog/data/raw/drive_map__ff9__verr_q.csv" value((v("/V_OutOL")-v("/V_InP")) 0.0)))
  )
)

;; ---- corner 10 (ff10) / test drive_map
when(isDir("/home/mseminario2/chips/castalia/ic/.simulation/castalia/anatop_tb_controlamp/maestro/results/maestro/Interactive.131/10/DriveMapTB/psf")
  openResults("/home/mseminario2/chips/castalia/ic/.simulation/castalia/anatop_tb_controlamp/maestro/results/maestro/Interactive.131/10/DriveMapTB/psf")
  when(member('dc results())
    selectResult('dc)
    mtxP = outfile("/home/mseminario2/vestarv/implementations/asic/castalia/analog/data/raw/drive_map__ff10.meta" "w")
    fprintf(mtxP "sweep %%L\n" car(errset(sweepNames())))
    close(mtxP)
    errset(mtxDump("/home/mseminario2/vestarv/implementations/asic/castalia/analog/data/raw/drive_map__ff10__i_sink.csv" cross((v("/V_OutOL")-v("/V_InP")) 0.05 1 "falling")))
    errset(mtxDump("/home/mseminario2/vestarv/implementations/asic/castalia/analog/data/raw/drive_map__ff10__i_span.csv" (cross((v("/V_OutOL")-v("/V_InP")) -0.05 1 "falling")-cross((v("/V_OutOL")-v("/V_InP")) 0.05 1 "falling"))))
    errset(mtxDump("/home/mseminario2/vestarv/implementations/asic/castalia/analog/data/raw/drive_map__ff10__i_src.csv" cross((v("/V_OutOL")-v("/V_InP")) -0.05 1 "falling")))
    errset(mtxDump("/home/mseminario2/vestarv/implementations/asic/castalia/analog/data/raw/drive_map__ff10__idd_q.csv" value(abs(i("/POWER/SRC_VDD25/PLUS")) 0.0)))
    errset(mtxDump("/home/mseminario2/vestarv/implementations/asic/castalia/analog/data/raw/drive_map__ff10__rout.csv" abs((value(v("/V_OutOL") 0.5e-6)-value(v("/V_OutOL") -0.5e-6))/1e-6)))
    errset(mtxDump("/home/mseminario2/vestarv/implementations/asic/castalia/analog/data/raw/drive_map__ff10__verr.csv" (v("/V_OutOL")-v("/V_InP"))))
    errset(mtxDump("/home/mseminario2/vestarv/implementations/asic/castalia/analog/data/raw/drive_map__ff10__verr_q.csv" value((v("/V_OutOL")-v("/V_InP")) 0.0)))
  )
)

;; ---- corner 11 (ff11) / test drive_map
when(isDir("/home/mseminario2/chips/castalia/ic/.simulation/castalia/anatop_tb_controlamp/maestro/results/maestro/Interactive.131/11/DriveMapTB/psf")
  openResults("/home/mseminario2/chips/castalia/ic/.simulation/castalia/anatop_tb_controlamp/maestro/results/maestro/Interactive.131/11/DriveMapTB/psf")
  when(member('dc results())
    selectResult('dc)
    mtxP = outfile("/home/mseminario2/vestarv/implementations/asic/castalia/analog/data/raw/drive_map__ff11.meta" "w")
    fprintf(mtxP "sweep %%L\n" car(errset(sweepNames())))
    close(mtxP)
    errset(mtxDump("/home/mseminario2/vestarv/implementations/asic/castalia/analog/data/raw/drive_map__ff11__i_sink.csv" cross((v("/V_OutOL")-v("/V_InP")) 0.05 1 "falling")))
    errset(mtxDump("/home/mseminario2/vestarv/implementations/asic/castalia/analog/data/raw/drive_map__ff11__i_span.csv" (cross((v("/V_OutOL")-v("/V_InP")) -0.05 1 "falling")-cross((v("/V_OutOL")-v("/V_InP")) 0.05 1 "falling"))))
    errset(mtxDump("/home/mseminario2/vestarv/implementations/asic/castalia/analog/data/raw/drive_map__ff11__i_src.csv" cross((v("/V_OutOL")-v("/V_InP")) -0.05 1 "falling")))
    errset(mtxDump("/home/mseminario2/vestarv/implementations/asic/castalia/analog/data/raw/drive_map__ff11__idd_q.csv" value(abs(i("/POWER/SRC_VDD25/PLUS")) 0.0)))
    errset(mtxDump("/home/mseminario2/vestarv/implementations/asic/castalia/analog/data/raw/drive_map__ff11__rout.csv" abs((value(v("/V_OutOL") 0.5e-6)-value(v("/V_OutOL") -0.5e-6))/1e-6)))
    errset(mtxDump("/home/mseminario2/vestarv/implementations/asic/castalia/analog/data/raw/drive_map__ff11__verr.csv" (v("/V_OutOL")-v("/V_InP"))))
    errset(mtxDump("/home/mseminario2/vestarv/implementations/asic/castalia/analog/data/raw/drive_map__ff11__verr_q.csv" value((v("/V_OutOL")-v("/V_InP")) 0.0)))
  )
)

;; ---- corner 12 (ff12) / test drive_map
when(isDir("/home/mseminario2/chips/castalia/ic/.simulation/castalia/anatop_tb_controlamp/maestro/results/maestro/Interactive.131/12/DriveMapTB/psf")
  openResults("/home/mseminario2/chips/castalia/ic/.simulation/castalia/anatop_tb_controlamp/maestro/results/maestro/Interactive.131/12/DriveMapTB/psf")
  when(member('dc results())
    selectResult('dc)
    mtxP = outfile("/home/mseminario2/vestarv/implementations/asic/castalia/analog/data/raw/drive_map__ff12.meta" "w")
    fprintf(mtxP "sweep %%L\n" car(errset(sweepNames())))
    close(mtxP)
    errset(mtxDump("/home/mseminario2/vestarv/implementations/asic/castalia/analog/data/raw/drive_map__ff12__i_sink.csv" cross((v("/V_OutOL")-v("/V_InP")) 0.05 1 "falling")))
    errset(mtxDump("/home/mseminario2/vestarv/implementations/asic/castalia/analog/data/raw/drive_map__ff12__i_span.csv" (cross((v("/V_OutOL")-v("/V_InP")) -0.05 1 "falling")-cross((v("/V_OutOL")-v("/V_InP")) 0.05 1 "falling"))))
    errset(mtxDump("/home/mseminario2/vestarv/implementations/asic/castalia/analog/data/raw/drive_map__ff12__i_src.csv" cross((v("/V_OutOL")-v("/V_InP")) -0.05 1 "falling")))
    errset(mtxDump("/home/mseminario2/vestarv/implementations/asic/castalia/analog/data/raw/drive_map__ff12__idd_q.csv" value(abs(i("/POWER/SRC_VDD25/PLUS")) 0.0)))
    errset(mtxDump("/home/mseminario2/vestarv/implementations/asic/castalia/analog/data/raw/drive_map__ff12__rout.csv" abs((value(v("/V_OutOL") 0.5e-6)-value(v("/V_OutOL") -0.5e-6))/1e-6)))
    errset(mtxDump("/home/mseminario2/vestarv/implementations/asic/castalia/analog/data/raw/drive_map__ff12__verr.csv" (v("/V_OutOL")-v("/V_InP"))))
    errset(mtxDump("/home/mseminario2/vestarv/implementations/asic/castalia/analog/data/raw/drive_map__ff12__verr_q.csv" value((v("/V_OutOL")-v("/V_InP")) 0.0)))
  )
)

;; ---- corner 13 (ff13) / test drive_map
when(isDir("/home/mseminario2/chips/castalia/ic/.simulation/castalia/anatop_tb_controlamp/maestro/results/maestro/Interactive.131/13/DriveMapTB/psf")
  openResults("/home/mseminario2/chips/castalia/ic/.simulation/castalia/anatop_tb_controlamp/maestro/results/maestro/Interactive.131/13/DriveMapTB/psf")
  when(member('dc results())
    selectResult('dc)
    mtxP = outfile("/home/mseminario2/vestarv/implementations/asic/castalia/analog/data/raw/drive_map__ff13.meta" "w")
    fprintf(mtxP "sweep %%L\n" car(errset(sweepNames())))
    close(mtxP)
    errset(mtxDump("/home/mseminario2/vestarv/implementations/asic/castalia/analog/data/raw/drive_map__ff13__i_sink.csv" cross((v("/V_OutOL")-v("/V_InP")) 0.05 1 "falling")))
    errset(mtxDump("/home/mseminario2/vestarv/implementations/asic/castalia/analog/data/raw/drive_map__ff13__i_span.csv" (cross((v("/V_OutOL")-v("/V_InP")) -0.05 1 "falling")-cross((v("/V_OutOL")-v("/V_InP")) 0.05 1 "falling"))))
    errset(mtxDump("/home/mseminario2/vestarv/implementations/asic/castalia/analog/data/raw/drive_map__ff13__i_src.csv" cross((v("/V_OutOL")-v("/V_InP")) -0.05 1 "falling")))
    errset(mtxDump("/home/mseminario2/vestarv/implementations/asic/castalia/analog/data/raw/drive_map__ff13__idd_q.csv" value(abs(i("/POWER/SRC_VDD25/PLUS")) 0.0)))
    errset(mtxDump("/home/mseminario2/vestarv/implementations/asic/castalia/analog/data/raw/drive_map__ff13__rout.csv" abs((value(v("/V_OutOL") 0.5e-6)-value(v("/V_OutOL") -0.5e-6))/1e-6)))
    errset(mtxDump("/home/mseminario2/vestarv/implementations/asic/castalia/analog/data/raw/drive_map__ff13__verr.csv" (v("/V_OutOL")-v("/V_InP"))))
    errset(mtxDump("/home/mseminario2/vestarv/implementations/asic/castalia/analog/data/raw/drive_map__ff13__verr_q.csv" value((v("/V_OutOL")-v("/V_InP")) 0.0)))
  )
)

;; ---- corner 14 (ff14) / test drive_map
when(isDir("/home/mseminario2/chips/castalia/ic/.simulation/castalia/anatop_tb_controlamp/maestro/results/maestro/Interactive.131/14/DriveMapTB/psf")
  openResults("/home/mseminario2/chips/castalia/ic/.simulation/castalia/anatop_tb_controlamp/maestro/results/maestro/Interactive.131/14/DriveMapTB/psf")
  when(member('dc results())
    selectResult('dc)
    mtxP = outfile("/home/mseminario2/vestarv/implementations/asic/castalia/analog/data/raw/drive_map__ff14.meta" "w")
    fprintf(mtxP "sweep %%L\n" car(errset(sweepNames())))
    close(mtxP)
    errset(mtxDump("/home/mseminario2/vestarv/implementations/asic/castalia/analog/data/raw/drive_map__ff14__i_sink.csv" cross((v("/V_OutOL")-v("/V_InP")) 0.05 1 "falling")))
    errset(mtxDump("/home/mseminario2/vestarv/implementations/asic/castalia/analog/data/raw/drive_map__ff14__i_span.csv" (cross((v("/V_OutOL")-v("/V_InP")) -0.05 1 "falling")-cross((v("/V_OutOL")-v("/V_InP")) 0.05 1 "falling"))))
    errset(mtxDump("/home/mseminario2/vestarv/implementations/asic/castalia/analog/data/raw/drive_map__ff14__i_src.csv" cross((v("/V_OutOL")-v("/V_InP")) -0.05 1 "falling")))
    errset(mtxDump("/home/mseminario2/vestarv/implementations/asic/castalia/analog/data/raw/drive_map__ff14__idd_q.csv" value(abs(i("/POWER/SRC_VDD25/PLUS")) 0.0)))
    errset(mtxDump("/home/mseminario2/vestarv/implementations/asic/castalia/analog/data/raw/drive_map__ff14__rout.csv" abs((value(v("/V_OutOL") 0.5e-6)-value(v("/V_OutOL") -0.5e-6))/1e-6)))
    errset(mtxDump("/home/mseminario2/vestarv/implementations/asic/castalia/analog/data/raw/drive_map__ff14__verr.csv" (v("/V_OutOL")-v("/V_InP"))))
    errset(mtxDump("/home/mseminario2/vestarv/implementations/asic/castalia/analog/data/raw/drive_map__ff14__verr_q.csv" value((v("/V_OutOL")-v("/V_InP")) 0.0)))
  )
)

;; ---- corner 15 (ff15) / test drive_map
when(isDir("/home/mseminario2/chips/castalia/ic/.simulation/castalia/anatop_tb_controlamp/maestro/results/maestro/Interactive.131/15/DriveMapTB/psf")
  openResults("/home/mseminario2/chips/castalia/ic/.simulation/castalia/anatop_tb_controlamp/maestro/results/maestro/Interactive.131/15/DriveMapTB/psf")
  when(member('dc results())
    selectResult('dc)
    mtxP = outfile("/home/mseminario2/vestarv/implementations/asic/castalia/analog/data/raw/drive_map__ff15.meta" "w")
    fprintf(mtxP "sweep %%L\n" car(errset(sweepNames())))
    close(mtxP)
    errset(mtxDump("/home/mseminario2/vestarv/implementations/asic/castalia/analog/data/raw/drive_map__ff15__i_sink.csv" cross((v("/V_OutOL")-v("/V_InP")) 0.05 1 "falling")))
    errset(mtxDump("/home/mseminario2/vestarv/implementations/asic/castalia/analog/data/raw/drive_map__ff15__i_span.csv" (cross((v("/V_OutOL")-v("/V_InP")) -0.05 1 "falling")-cross((v("/V_OutOL")-v("/V_InP")) 0.05 1 "falling"))))
    errset(mtxDump("/home/mseminario2/vestarv/implementations/asic/castalia/analog/data/raw/drive_map__ff15__i_src.csv" cross((v("/V_OutOL")-v("/V_InP")) -0.05 1 "falling")))
    errset(mtxDump("/home/mseminario2/vestarv/implementations/asic/castalia/analog/data/raw/drive_map__ff15__idd_q.csv" value(abs(i("/POWER/SRC_VDD25/PLUS")) 0.0)))
    errset(mtxDump("/home/mseminario2/vestarv/implementations/asic/castalia/analog/data/raw/drive_map__ff15__rout.csv" abs((value(v("/V_OutOL") 0.5e-6)-value(v("/V_OutOL") -0.5e-6))/1e-6)))
    errset(mtxDump("/home/mseminario2/vestarv/implementations/asic/castalia/analog/data/raw/drive_map__ff15__verr.csv" (v("/V_OutOL")-v("/V_InP"))))
    errset(mtxDump("/home/mseminario2/vestarv/implementations/asic/castalia/analog/data/raw/drive_map__ff15__verr_q.csv" value((v("/V_OutOL")-v("/V_InP")) 0.0)))
  )
)

;; ---- corner 16 (ff16) / test drive_map
when(isDir("/home/mseminario2/chips/castalia/ic/.simulation/castalia/anatop_tb_controlamp/maestro/results/maestro/Interactive.131/16/DriveMapTB/psf")
  openResults("/home/mseminario2/chips/castalia/ic/.simulation/castalia/anatop_tb_controlamp/maestro/results/maestro/Interactive.131/16/DriveMapTB/psf")
  when(member('dc results())
    selectResult('dc)
    mtxP = outfile("/home/mseminario2/vestarv/implementations/asic/castalia/analog/data/raw/drive_map__ff16.meta" "w")
    fprintf(mtxP "sweep %%L\n" car(errset(sweepNames())))
    close(mtxP)
    errset(mtxDump("/home/mseminario2/vestarv/implementations/asic/castalia/analog/data/raw/drive_map__ff16__i_sink.csv" cross((v("/V_OutOL")-v("/V_InP")) 0.05 1 "falling")))
    errset(mtxDump("/home/mseminario2/vestarv/implementations/asic/castalia/analog/data/raw/drive_map__ff16__i_span.csv" (cross((v("/V_OutOL")-v("/V_InP")) -0.05 1 "falling")-cross((v("/V_OutOL")-v("/V_InP")) 0.05 1 "falling"))))
    errset(mtxDump("/home/mseminario2/vestarv/implementations/asic/castalia/analog/data/raw/drive_map__ff16__i_src.csv" cross((v("/V_OutOL")-v("/V_InP")) -0.05 1 "falling")))
    errset(mtxDump("/home/mseminario2/vestarv/implementations/asic/castalia/analog/data/raw/drive_map__ff16__idd_q.csv" value(abs(i("/POWER/SRC_VDD25/PLUS")) 0.0)))
    errset(mtxDump("/home/mseminario2/vestarv/implementations/asic/castalia/analog/data/raw/drive_map__ff16__rout.csv" abs((value(v("/V_OutOL") 0.5e-6)-value(v("/V_OutOL") -0.5e-6))/1e-6)))
    errset(mtxDump("/home/mseminario2/vestarv/implementations/asic/castalia/analog/data/raw/drive_map__ff16__verr.csv" (v("/V_OutOL")-v("/V_InP"))))
    errset(mtxDump("/home/mseminario2/vestarv/implementations/asic/castalia/analog/data/raw/drive_map__ff16__verr_q.csv" value((v("/V_OutOL")-v("/V_InP")) 0.0)))
  )
)

;; ---- corner 17 (ff17) / test drive_map
when(isDir("/home/mseminario2/chips/castalia/ic/.simulation/castalia/anatop_tb_controlamp/maestro/results/maestro/Interactive.131/17/DriveMapTB/psf")
  openResults("/home/mseminario2/chips/castalia/ic/.simulation/castalia/anatop_tb_controlamp/maestro/results/maestro/Interactive.131/17/DriveMapTB/psf")
  when(member('dc results())
    selectResult('dc)
    mtxP = outfile("/home/mseminario2/vestarv/implementations/asic/castalia/analog/data/raw/drive_map__ff17.meta" "w")
    fprintf(mtxP "sweep %%L\n" car(errset(sweepNames())))
    close(mtxP)
    errset(mtxDump("/home/mseminario2/vestarv/implementations/asic/castalia/analog/data/raw/drive_map__ff17__i_sink.csv" cross((v("/V_OutOL")-v("/V_InP")) 0.05 1 "falling")))
    errset(mtxDump("/home/mseminario2/vestarv/implementations/asic/castalia/analog/data/raw/drive_map__ff17__i_span.csv" (cross((v("/V_OutOL")-v("/V_InP")) -0.05 1 "falling")-cross((v("/V_OutOL")-v("/V_InP")) 0.05 1 "falling"))))
    errset(mtxDump("/home/mseminario2/vestarv/implementations/asic/castalia/analog/data/raw/drive_map__ff17__i_src.csv" cross((v("/V_OutOL")-v("/V_InP")) -0.05 1 "falling")))
    errset(mtxDump("/home/mseminario2/vestarv/implementations/asic/castalia/analog/data/raw/drive_map__ff17__idd_q.csv" value(abs(i("/POWER/SRC_VDD25/PLUS")) 0.0)))
    errset(mtxDump("/home/mseminario2/vestarv/implementations/asic/castalia/analog/data/raw/drive_map__ff17__rout.csv" abs((value(v("/V_OutOL") 0.5e-6)-value(v("/V_OutOL") -0.5e-6))/1e-6)))
    errset(mtxDump("/home/mseminario2/vestarv/implementations/asic/castalia/analog/data/raw/drive_map__ff17__verr.csv" (v("/V_OutOL")-v("/V_InP"))))
    errset(mtxDump("/home/mseminario2/vestarv/implementations/asic/castalia/analog/data/raw/drive_map__ff17__verr_q.csv" value((v("/V_OutOL")-v("/V_InP")) 0.0)))
  )
)

;; ---- corner 18 (ff18) / test drive_map
when(isDir("/home/mseminario2/chips/castalia/ic/.simulation/castalia/anatop_tb_controlamp/maestro/results/maestro/Interactive.131/18/DriveMapTB/psf")
  openResults("/home/mseminario2/chips/castalia/ic/.simulation/castalia/anatop_tb_controlamp/maestro/results/maestro/Interactive.131/18/DriveMapTB/psf")
  when(member('dc results())
    selectResult('dc)
    mtxP = outfile("/home/mseminario2/vestarv/implementations/asic/castalia/analog/data/raw/drive_map__ff18.meta" "w")
    fprintf(mtxP "sweep %%L\n" car(errset(sweepNames())))
    close(mtxP)
    errset(mtxDump("/home/mseminario2/vestarv/implementations/asic/castalia/analog/data/raw/drive_map__ff18__i_sink.csv" cross((v("/V_OutOL")-v("/V_InP")) 0.05 1 "falling")))
    errset(mtxDump("/home/mseminario2/vestarv/implementations/asic/castalia/analog/data/raw/drive_map__ff18__i_span.csv" (cross((v("/V_OutOL")-v("/V_InP")) -0.05 1 "falling")-cross((v("/V_OutOL")-v("/V_InP")) 0.05 1 "falling"))))
    errset(mtxDump("/home/mseminario2/vestarv/implementations/asic/castalia/analog/data/raw/drive_map__ff18__i_src.csv" cross((v("/V_OutOL")-v("/V_InP")) -0.05 1 "falling")))
    errset(mtxDump("/home/mseminario2/vestarv/implementations/asic/castalia/analog/data/raw/drive_map__ff18__idd_q.csv" value(abs(i("/POWER/SRC_VDD25/PLUS")) 0.0)))
    errset(mtxDump("/home/mseminario2/vestarv/implementations/asic/castalia/analog/data/raw/drive_map__ff18__rout.csv" abs((value(v("/V_OutOL") 0.5e-6)-value(v("/V_OutOL") -0.5e-6))/1e-6)))
    errset(mtxDump("/home/mseminario2/vestarv/implementations/asic/castalia/analog/data/raw/drive_map__ff18__verr.csv" (v("/V_OutOL")-v("/V_InP"))))
    errset(mtxDump("/home/mseminario2/vestarv/implementations/asic/castalia/analog/data/raw/drive_map__ff18__verr_q.csv" value((v("/V_OutOL")-v("/V_InP")) 0.0)))
  )
)

;; ---- corner 19 (ff19) / test drive_map
when(isDir("/home/mseminario2/chips/castalia/ic/.simulation/castalia/anatop_tb_controlamp/maestro/results/maestro/Interactive.131/19/DriveMapTB/psf")
  openResults("/home/mseminario2/chips/castalia/ic/.simulation/castalia/anatop_tb_controlamp/maestro/results/maestro/Interactive.131/19/DriveMapTB/psf")
  when(member('dc results())
    selectResult('dc)
    mtxP = outfile("/home/mseminario2/vestarv/implementations/asic/castalia/analog/data/raw/drive_map__ff19.meta" "w")
    fprintf(mtxP "sweep %%L\n" car(errset(sweepNames())))
    close(mtxP)
    errset(mtxDump("/home/mseminario2/vestarv/implementations/asic/castalia/analog/data/raw/drive_map__ff19__i_sink.csv" cross((v("/V_OutOL")-v("/V_InP")) 0.05 1 "falling")))
    errset(mtxDump("/home/mseminario2/vestarv/implementations/asic/castalia/analog/data/raw/drive_map__ff19__i_span.csv" (cross((v("/V_OutOL")-v("/V_InP")) -0.05 1 "falling")-cross((v("/V_OutOL")-v("/V_InP")) 0.05 1 "falling"))))
    errset(mtxDump("/home/mseminario2/vestarv/implementations/asic/castalia/analog/data/raw/drive_map__ff19__i_src.csv" cross((v("/V_OutOL")-v("/V_InP")) -0.05 1 "falling")))
    errset(mtxDump("/home/mseminario2/vestarv/implementations/asic/castalia/analog/data/raw/drive_map__ff19__idd_q.csv" value(abs(i("/POWER/SRC_VDD25/PLUS")) 0.0)))
    errset(mtxDump("/home/mseminario2/vestarv/implementations/asic/castalia/analog/data/raw/drive_map__ff19__rout.csv" abs((value(v("/V_OutOL") 0.5e-6)-value(v("/V_OutOL") -0.5e-6))/1e-6)))
    errset(mtxDump("/home/mseminario2/vestarv/implementations/asic/castalia/analog/data/raw/drive_map__ff19__verr.csv" (v("/V_OutOL")-v("/V_InP"))))
    errset(mtxDump("/home/mseminario2/vestarv/implementations/asic/castalia/analog/data/raw/drive_map__ff19__verr_q.csv" value((v("/V_OutOL")-v("/V_InP")) 0.0)))
  )
)

;; ---- corner 20 (ff20) / test drive_map
when(isDir("/home/mseminario2/chips/castalia/ic/.simulation/castalia/anatop_tb_controlamp/maestro/results/maestro/Interactive.131/20/DriveMapTB/psf")
  openResults("/home/mseminario2/chips/castalia/ic/.simulation/castalia/anatop_tb_controlamp/maestro/results/maestro/Interactive.131/20/DriveMapTB/psf")
  when(member('dc results())
    selectResult('dc)
    mtxP = outfile("/home/mseminario2/vestarv/implementations/asic/castalia/analog/data/raw/drive_map__ff20.meta" "w")
    fprintf(mtxP "sweep %%L\n" car(errset(sweepNames())))
    close(mtxP)
    errset(mtxDump("/home/mseminario2/vestarv/implementations/asic/castalia/analog/data/raw/drive_map__ff20__i_sink.csv" cross((v("/V_OutOL")-v("/V_InP")) 0.05 1 "falling")))
    errset(mtxDump("/home/mseminario2/vestarv/implementations/asic/castalia/analog/data/raw/drive_map__ff20__i_span.csv" (cross((v("/V_OutOL")-v("/V_InP")) -0.05 1 "falling")-cross((v("/V_OutOL")-v("/V_InP")) 0.05 1 "falling"))))
    errset(mtxDump("/home/mseminario2/vestarv/implementations/asic/castalia/analog/data/raw/drive_map__ff20__i_src.csv" cross((v("/V_OutOL")-v("/V_InP")) -0.05 1 "falling")))
    errset(mtxDump("/home/mseminario2/vestarv/implementations/asic/castalia/analog/data/raw/drive_map__ff20__idd_q.csv" value(abs(i("/POWER/SRC_VDD25/PLUS")) 0.0)))
    errset(mtxDump("/home/mseminario2/vestarv/implementations/asic/castalia/analog/data/raw/drive_map__ff20__rout.csv" abs((value(v("/V_OutOL") 0.5e-6)-value(v("/V_OutOL") -0.5e-6))/1e-6)))
    errset(mtxDump("/home/mseminario2/vestarv/implementations/asic/castalia/analog/data/raw/drive_map__ff20__verr.csv" (v("/V_OutOL")-v("/V_InP"))))
    errset(mtxDump("/home/mseminario2/vestarv/implementations/asic/castalia/analog/data/raw/drive_map__ff20__verr_q.csv" value((v("/V_OutOL")-v("/V_InP")) 0.0)))
  )
)

;; ---- corner 21 (ff21) / test drive_map
when(isDir("/home/mseminario2/chips/castalia/ic/.simulation/castalia/anatop_tb_controlamp/maestro/results/maestro/Interactive.131/21/DriveMapTB/psf")
  openResults("/home/mseminario2/chips/castalia/ic/.simulation/castalia/anatop_tb_controlamp/maestro/results/maestro/Interactive.131/21/DriveMapTB/psf")
  when(member('dc results())
    selectResult('dc)
    mtxP = outfile("/home/mseminario2/vestarv/implementations/asic/castalia/analog/data/raw/drive_map__ff21.meta" "w")
    fprintf(mtxP "sweep %%L\n" car(errset(sweepNames())))
    close(mtxP)
    errset(mtxDump("/home/mseminario2/vestarv/implementations/asic/castalia/analog/data/raw/drive_map__ff21__i_sink.csv" cross((v("/V_OutOL")-v("/V_InP")) 0.05 1 "falling")))
    errset(mtxDump("/home/mseminario2/vestarv/implementations/asic/castalia/analog/data/raw/drive_map__ff21__i_span.csv" (cross((v("/V_OutOL")-v("/V_InP")) -0.05 1 "falling")-cross((v("/V_OutOL")-v("/V_InP")) 0.05 1 "falling"))))
    errset(mtxDump("/home/mseminario2/vestarv/implementations/asic/castalia/analog/data/raw/drive_map__ff21__i_src.csv" cross((v("/V_OutOL")-v("/V_InP")) -0.05 1 "falling")))
    errset(mtxDump("/home/mseminario2/vestarv/implementations/asic/castalia/analog/data/raw/drive_map__ff21__idd_q.csv" value(abs(i("/POWER/SRC_VDD25/PLUS")) 0.0)))
    errset(mtxDump("/home/mseminario2/vestarv/implementations/asic/castalia/analog/data/raw/drive_map__ff21__rout.csv" abs((value(v("/V_OutOL") 0.5e-6)-value(v("/V_OutOL") -0.5e-6))/1e-6)))
    errset(mtxDump("/home/mseminario2/vestarv/implementations/asic/castalia/analog/data/raw/drive_map__ff21__verr.csv" (v("/V_OutOL")-v("/V_InP"))))
    errset(mtxDump("/home/mseminario2/vestarv/implementations/asic/castalia/analog/data/raw/drive_map__ff21__verr_q.csv" value((v("/V_OutOL")-v("/V_InP")) 0.0)))
  )
)

;; ---- corner 22 (ff22) / test drive_map
when(isDir("/home/mseminario2/chips/castalia/ic/.simulation/castalia/anatop_tb_controlamp/maestro/results/maestro/Interactive.131/22/DriveMapTB/psf")
  openResults("/home/mseminario2/chips/castalia/ic/.simulation/castalia/anatop_tb_controlamp/maestro/results/maestro/Interactive.131/22/DriveMapTB/psf")
  when(member('dc results())
    selectResult('dc)
    mtxP = outfile("/home/mseminario2/vestarv/implementations/asic/castalia/analog/data/raw/drive_map__ff22.meta" "w")
    fprintf(mtxP "sweep %%L\n" car(errset(sweepNames())))
    close(mtxP)
    errset(mtxDump("/home/mseminario2/vestarv/implementations/asic/castalia/analog/data/raw/drive_map__ff22__i_sink.csv" cross((v("/V_OutOL")-v("/V_InP")) 0.05 1 "falling")))
    errset(mtxDump("/home/mseminario2/vestarv/implementations/asic/castalia/analog/data/raw/drive_map__ff22__i_span.csv" (cross((v("/V_OutOL")-v("/V_InP")) -0.05 1 "falling")-cross((v("/V_OutOL")-v("/V_InP")) 0.05 1 "falling"))))
    errset(mtxDump("/home/mseminario2/vestarv/implementations/asic/castalia/analog/data/raw/drive_map__ff22__i_src.csv" cross((v("/V_OutOL")-v("/V_InP")) -0.05 1 "falling")))
    errset(mtxDump("/home/mseminario2/vestarv/implementations/asic/castalia/analog/data/raw/drive_map__ff22__idd_q.csv" value(abs(i("/POWER/SRC_VDD25/PLUS")) 0.0)))
    errset(mtxDump("/home/mseminario2/vestarv/implementations/asic/castalia/analog/data/raw/drive_map__ff22__rout.csv" abs((value(v("/V_OutOL") 0.5e-6)-value(v("/V_OutOL") -0.5e-6))/1e-6)))
    errset(mtxDump("/home/mseminario2/vestarv/implementations/asic/castalia/analog/data/raw/drive_map__ff22__verr.csv" (v("/V_OutOL")-v("/V_InP"))))
    errset(mtxDump("/home/mseminario2/vestarv/implementations/asic/castalia/analog/data/raw/drive_map__ff22__verr_q.csv" value((v("/V_OutOL")-v("/V_InP")) 0.0)))
  )
)

;; ---- corner 23 (ff23) / test drive_map
when(isDir("/home/mseminario2/chips/castalia/ic/.simulation/castalia/anatop_tb_controlamp/maestro/results/maestro/Interactive.131/23/DriveMapTB/psf")
  openResults("/home/mseminario2/chips/castalia/ic/.simulation/castalia/anatop_tb_controlamp/maestro/results/maestro/Interactive.131/23/DriveMapTB/psf")
  when(member('dc results())
    selectResult('dc)
    mtxP = outfile("/home/mseminario2/vestarv/implementations/asic/castalia/analog/data/raw/drive_map__ff23.meta" "w")
    fprintf(mtxP "sweep %%L\n" car(errset(sweepNames())))
    close(mtxP)
    errset(mtxDump("/home/mseminario2/vestarv/implementations/asic/castalia/analog/data/raw/drive_map__ff23__i_sink.csv" cross((v("/V_OutOL")-v("/V_InP")) 0.05 1 "falling")))
    errset(mtxDump("/home/mseminario2/vestarv/implementations/asic/castalia/analog/data/raw/drive_map__ff23__i_span.csv" (cross((v("/V_OutOL")-v("/V_InP")) -0.05 1 "falling")-cross((v("/V_OutOL")-v("/V_InP")) 0.05 1 "falling"))))
    errset(mtxDump("/home/mseminario2/vestarv/implementations/asic/castalia/analog/data/raw/drive_map__ff23__i_src.csv" cross((v("/V_OutOL")-v("/V_InP")) -0.05 1 "falling")))
    errset(mtxDump("/home/mseminario2/vestarv/implementations/asic/castalia/analog/data/raw/drive_map__ff23__idd_q.csv" value(abs(i("/POWER/SRC_VDD25/PLUS")) 0.0)))
    errset(mtxDump("/home/mseminario2/vestarv/implementations/asic/castalia/analog/data/raw/drive_map__ff23__rout.csv" abs((value(v("/V_OutOL") 0.5e-6)-value(v("/V_OutOL") -0.5e-6))/1e-6)))
    errset(mtxDump("/home/mseminario2/vestarv/implementations/asic/castalia/analog/data/raw/drive_map__ff23__verr.csv" (v("/V_OutOL")-v("/V_InP"))))
    errset(mtxDump("/home/mseminario2/vestarv/implementations/asic/castalia/analog/data/raw/drive_map__ff23__verr_q.csv" value((v("/V_OutOL")-v("/V_InP")) 0.0)))
  )
)

;; ---- corner 24 (ff24) / test drive_map
when(isDir("/home/mseminario2/chips/castalia/ic/.simulation/castalia/anatop_tb_controlamp/maestro/results/maestro/Interactive.131/24/DriveMapTB/psf")
  openResults("/home/mseminario2/chips/castalia/ic/.simulation/castalia/anatop_tb_controlamp/maestro/results/maestro/Interactive.131/24/DriveMapTB/psf")
  when(member('dc results())
    selectResult('dc)
    mtxP = outfile("/home/mseminario2/vestarv/implementations/asic/castalia/analog/data/raw/drive_map__ff24.meta" "w")
    fprintf(mtxP "sweep %%L\n" car(errset(sweepNames())))
    close(mtxP)
    errset(mtxDump("/home/mseminario2/vestarv/implementations/asic/castalia/analog/data/raw/drive_map__ff24__i_sink.csv" cross((v("/V_OutOL")-v("/V_InP")) 0.05 1 "falling")))
    errset(mtxDump("/home/mseminario2/vestarv/implementations/asic/castalia/analog/data/raw/drive_map__ff24__i_span.csv" (cross((v("/V_OutOL")-v("/V_InP")) -0.05 1 "falling")-cross((v("/V_OutOL")-v("/V_InP")) 0.05 1 "falling"))))
    errset(mtxDump("/home/mseminario2/vestarv/implementations/asic/castalia/analog/data/raw/drive_map__ff24__i_src.csv" cross((v("/V_OutOL")-v("/V_InP")) -0.05 1 "falling")))
    errset(mtxDump("/home/mseminario2/vestarv/implementations/asic/castalia/analog/data/raw/drive_map__ff24__idd_q.csv" value(abs(i("/POWER/SRC_VDD25/PLUS")) 0.0)))
    errset(mtxDump("/home/mseminario2/vestarv/implementations/asic/castalia/analog/data/raw/drive_map__ff24__rout.csv" abs((value(v("/V_OutOL") 0.5e-6)-value(v("/V_OutOL") -0.5e-6))/1e-6)))
    errset(mtxDump("/home/mseminario2/vestarv/implementations/asic/castalia/analog/data/raw/drive_map__ff24__verr.csv" (v("/V_OutOL")-v("/V_InP"))))
    errset(mtxDump("/home/mseminario2/vestarv/implementations/asic/castalia/analog/data/raw/drive_map__ff24__verr_q.csv" value((v("/V_OutOL")-v("/V_InP")) 0.0)))
  )
)

;; ---- corner 25 (ff25) / test drive_map
when(isDir("/home/mseminario2/chips/castalia/ic/.simulation/castalia/anatop_tb_controlamp/maestro/results/maestro/Interactive.131/25/DriveMapTB/psf")
  openResults("/home/mseminario2/chips/castalia/ic/.simulation/castalia/anatop_tb_controlamp/maestro/results/maestro/Interactive.131/25/DriveMapTB/psf")
  when(member('dc results())
    selectResult('dc)
    mtxP = outfile("/home/mseminario2/vestarv/implementations/asic/castalia/analog/data/raw/drive_map__ff25.meta" "w")
    fprintf(mtxP "sweep %%L\n" car(errset(sweepNames())))
    close(mtxP)
    errset(mtxDump("/home/mseminario2/vestarv/implementations/asic/castalia/analog/data/raw/drive_map__ff25__i_sink.csv" cross((v("/V_OutOL")-v("/V_InP")) 0.05 1 "falling")))
    errset(mtxDump("/home/mseminario2/vestarv/implementations/asic/castalia/analog/data/raw/drive_map__ff25__i_span.csv" (cross((v("/V_OutOL")-v("/V_InP")) -0.05 1 "falling")-cross((v("/V_OutOL")-v("/V_InP")) 0.05 1 "falling"))))
    errset(mtxDump("/home/mseminario2/vestarv/implementations/asic/castalia/analog/data/raw/drive_map__ff25__i_src.csv" cross((v("/V_OutOL")-v("/V_InP")) -0.05 1 "falling")))
    errset(mtxDump("/home/mseminario2/vestarv/implementations/asic/castalia/analog/data/raw/drive_map__ff25__idd_q.csv" value(abs(i("/POWER/SRC_VDD25/PLUS")) 0.0)))
    errset(mtxDump("/home/mseminario2/vestarv/implementations/asic/castalia/analog/data/raw/drive_map__ff25__rout.csv" abs((value(v("/V_OutOL") 0.5e-6)-value(v("/V_OutOL") -0.5e-6))/1e-6)))
    errset(mtxDump("/home/mseminario2/vestarv/implementations/asic/castalia/analog/data/raw/drive_map__ff25__verr.csv" (v("/V_OutOL")-v("/V_InP"))))
    errset(mtxDump("/home/mseminario2/vestarv/implementations/asic/castalia/analog/data/raw/drive_map__ff25__verr_q.csv" value((v("/V_OutOL")-v("/V_InP")) 0.0)))
  )
)

;; ---- corner 26 (ff26) / test drive_map
when(isDir("/home/mseminario2/chips/castalia/ic/.simulation/castalia/anatop_tb_controlamp/maestro/results/maestro/Interactive.131/26/DriveMapTB/psf")
  openResults("/home/mseminario2/chips/castalia/ic/.simulation/castalia/anatop_tb_controlamp/maestro/results/maestro/Interactive.131/26/DriveMapTB/psf")
  when(member('dc results())
    selectResult('dc)
    mtxP = outfile("/home/mseminario2/vestarv/implementations/asic/castalia/analog/data/raw/drive_map__ff26.meta" "w")
    fprintf(mtxP "sweep %%L\n" car(errset(sweepNames())))
    close(mtxP)
    errset(mtxDump("/home/mseminario2/vestarv/implementations/asic/castalia/analog/data/raw/drive_map__ff26__i_sink.csv" cross((v("/V_OutOL")-v("/V_InP")) 0.05 1 "falling")))
    errset(mtxDump("/home/mseminario2/vestarv/implementations/asic/castalia/analog/data/raw/drive_map__ff26__i_span.csv" (cross((v("/V_OutOL")-v("/V_InP")) -0.05 1 "falling")-cross((v("/V_OutOL")-v("/V_InP")) 0.05 1 "falling"))))
    errset(mtxDump("/home/mseminario2/vestarv/implementations/asic/castalia/analog/data/raw/drive_map__ff26__i_src.csv" cross((v("/V_OutOL")-v("/V_InP")) -0.05 1 "falling")))
    errset(mtxDump("/home/mseminario2/vestarv/implementations/asic/castalia/analog/data/raw/drive_map__ff26__idd_q.csv" value(abs(i("/POWER/SRC_VDD25/PLUS")) 0.0)))
    errset(mtxDump("/home/mseminario2/vestarv/implementations/asic/castalia/analog/data/raw/drive_map__ff26__rout.csv" abs((value(v("/V_OutOL") 0.5e-6)-value(v("/V_OutOL") -0.5e-6))/1e-6)))
    errset(mtxDump("/home/mseminario2/vestarv/implementations/asic/castalia/analog/data/raw/drive_map__ff26__verr.csv" (v("/V_OutOL")-v("/V_InP"))))
    errset(mtxDump("/home/mseminario2/vestarv/implementations/asic/castalia/analog/data/raw/drive_map__ff26__verr_q.csv" value((v("/V_OutOL")-v("/V_InP")) 0.0)))
  )
)

;; ---- corner 27 (ff27) / test drive_map
when(isDir("/home/mseminario2/chips/castalia/ic/.simulation/castalia/anatop_tb_controlamp/maestro/results/maestro/Interactive.131/27/DriveMapTB/psf")
  openResults("/home/mseminario2/chips/castalia/ic/.simulation/castalia/anatop_tb_controlamp/maestro/results/maestro/Interactive.131/27/DriveMapTB/psf")
  when(member('dc results())
    selectResult('dc)
    mtxP = outfile("/home/mseminario2/vestarv/implementations/asic/castalia/analog/data/raw/drive_map__ff27.meta" "w")
    fprintf(mtxP "sweep %%L\n" car(errset(sweepNames())))
    close(mtxP)
    errset(mtxDump("/home/mseminario2/vestarv/implementations/asic/castalia/analog/data/raw/drive_map__ff27__i_sink.csv" cross((v("/V_OutOL")-v("/V_InP")) 0.05 1 "falling")))
    errset(mtxDump("/home/mseminario2/vestarv/implementations/asic/castalia/analog/data/raw/drive_map__ff27__i_span.csv" (cross((v("/V_OutOL")-v("/V_InP")) -0.05 1 "falling")-cross((v("/V_OutOL")-v("/V_InP")) 0.05 1 "falling"))))
    errset(mtxDump("/home/mseminario2/vestarv/implementations/asic/castalia/analog/data/raw/drive_map__ff27__i_src.csv" cross((v("/V_OutOL")-v("/V_InP")) -0.05 1 "falling")))
    errset(mtxDump("/home/mseminario2/vestarv/implementations/asic/castalia/analog/data/raw/drive_map__ff27__idd_q.csv" value(abs(i("/POWER/SRC_VDD25/PLUS")) 0.0)))
    errset(mtxDump("/home/mseminario2/vestarv/implementations/asic/castalia/analog/data/raw/drive_map__ff27__rout.csv" abs((value(v("/V_OutOL") 0.5e-6)-value(v("/V_OutOL") -0.5e-6))/1e-6)))
    errset(mtxDump("/home/mseminario2/vestarv/implementations/asic/castalia/analog/data/raw/drive_map__ff27__verr.csv" (v("/V_OutOL")-v("/V_InP"))))
    errset(mtxDump("/home/mseminario2/vestarv/implementations/asic/castalia/analog/data/raw/drive_map__ff27__verr_q.csv" value((v("/V_OutOL")-v("/V_InP")) 0.0)))
  )
)

printf("MTX_EXTRACT_DONE\n")
exit(0)
