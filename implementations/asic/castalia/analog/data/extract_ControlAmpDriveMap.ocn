;; generated by maestro2tex -- do not edit
procedure(mtxDump(fname wv)
  let((xs ys n p)
    p = outfile(fname "w")
    cond(
      (null(wv) fprintf(p "#nil\n"))
      (drIsWaveform(wv)
        xs = drGetWaveformXVec(wv)
        ys = drGetWaveformYVec(wv)
        n = drVectorLength(xs)
        for(i 0 n-1
          fprintf(p "%.10g %.10g\n" drGetElem(xs i) drGetElem(ys i)))
      )
      (t fprintf(p "#scalar %.10g\n" float(wv)))
    )
    close(p)
    t))

;; ---- corner 1 (tt1) / test drive_map
when(isDir("/home/mseminario2/chips/castalia/simarchive/anatop_tb_controlamp/Interactive.137/1/DriveMapTB/psf")
  openResults("/home/mseminario2/chips/castalia/simarchive/anatop_tb_controlamp/Interactive.137/1/DriveMapTB/psf")
  when(member('dc results())
    selectResult('dc)
    mtxP = outfile("/home/mseminario2/vestarv/implementations/asic/castalia/analog/data/raw/drive_map__tt1.meta" "w")
    fprintf(mtxP "sweep %%L\n" car(errset(sweepNames())))
    close(mtxP)
    errset(mtxDump("/home/mseminario2/vestarv/implementations/asic/castalia/analog/data/raw/drive_map__tt1__i_sink.csv" cross((v("/V_OutOL")-v("/V_InP")) 0.05 1 "falling")))
    errset(mtxDump("/home/mseminario2/vestarv/implementations/asic/castalia/analog/data/raw/drive_map__tt1__i_span.csv" (cross((v("/V_OutOL")-v("/V_InP")) -0.05 1 "falling")-cross((v("/V_OutOL")-v("/V_InP")) 0.05 1 "falling"))))
    errset(mtxDump("/home/mseminario2/vestarv/implementations/asic/castalia/analog/data/raw/drive_map__tt1__i_src.csv" cross((v("/V_OutOL")-v("/V_InP")) -0.05 1 "falling")))
    errset(mtxDump("/home/mseminario2/vestarv/implementations/asic/castalia/analog/data/raw/drive_map__tt1__idd_q.csv" value(abs(i("/POWER/SRC_VDD25/PLUS")) 0.0)))
    errset(mtxDump("/home/mseminario2/vestarv/implementations/asic/castalia/analog/data/raw/drive_map__tt1__rout.csv" abs((value(v("/V_OutOL") 0.5e-6)-value(v("/V_OutOL") -0.5e-6))/1e-6)))
    errset(mtxDump("/home/mseminario2/vestarv/implementations/asic/castalia/analog/data/raw/drive_map__tt1__verr.csv" (v("/V_OutOL")-v("/V_InP"))))
    errset(mtxDump("/home/mseminario2/vestarv/implementations/asic/castalia/analog/data/raw/drive_map__tt1__verr_q.csv" value((v("/V_OutOL")-v("/V_InP")) 0.0)))
  )
)

;; ---- corner 2 (ff2) / test drive_map
when(isDir("/home/mseminario2/chips/castalia/simarchive/anatop_tb_controlamp/Interactive.137/2/DriveMapTB/psf")
  openResults("/home/mseminario2/chips/castalia/simarchive/anatop_tb_controlamp/Interactive.137/2/DriveMapTB/psf")
  when(member('dc results())
    selectResult('dc)
    mtxP = outfile("/home/mseminario2/vestarv/implementations/asic/castalia/analog/data/raw/drive_map__ff2.meta" "w")
    fprintf(mtxP "sweep %%L\n" car(errset(sweepNames())))
    close(mtxP)
    errset(mtxDump("/home/mseminario2/vestarv/implementations/asic/castalia/analog/data/raw/drive_map__ff2__i_sink.csv" cross((v("/V_OutOL")-v("/V_InP")) 0.05 1 "falling")))
    errset(mtxDump("/home/mseminario2/vestarv/implementations/asic/castalia/analog/data/raw/drive_map__ff2__i_span.csv" (cross((v("/V_OutOL")-v("/V_InP")) -0.05 1 "falling")-cross((v("/V_OutOL")-v("/V_InP")) 0.05 1 "falling"))))
    errset(mtxDump("/home/mseminario2/vestarv/implementations/asic/castalia/analog/data/raw/drive_map__ff2__i_src.csv" cross((v("/V_OutOL")-v("/V_InP")) -0.05 1 "falling")))
    errset(mtxDump("/home/mseminario2/vestarv/implementations/asic/castalia/analog/data/raw/drive_map__ff2__idd_q.csv" value(abs(i("/POWER/SRC_VDD25/PLUS")) 0.0)))
    errset(mtxDump("/home/mseminario2/vestarv/implementations/asic/castalia/analog/data/raw/drive_map__ff2__rout.csv" abs((value(v("/V_OutOL") 0.5e-6)-value(v("/V_OutOL") -0.5e-6))/1e-6)))
    errset(mtxDump("/home/mseminario2/vestarv/implementations/asic/castalia/analog/data/raw/drive_map__ff2__verr.csv" (v("/V_OutOL")-v("/V_InP"))))
    errset(mtxDump("/home/mseminario2/vestarv/implementations/asic/castalia/analog/data/raw/drive_map__ff2__verr_q.csv" value((v("/V_OutOL")-v("/V_InP")) 0.0)))
  )
)

;; ---- corner 3 (fs3) / test drive_map
when(isDir("/home/mseminario2/chips/castalia/simarchive/anatop_tb_controlamp/Interactive.137/3/DriveMapTB/psf")
  openResults("/home/mseminario2/chips/castalia/simarchive/anatop_tb_controlamp/Interactive.137/3/DriveMapTB/psf")
  when(member('dc results())
    selectResult('dc)
    mtxP = outfile("/home/mseminario2/vestarv/implementations/asic/castalia/analog/data/raw/drive_map__fs3.meta" "w")
    fprintf(mtxP "sweep %%L\n" car(errset(sweepNames())))
    close(mtxP)
    errset(mtxDump("/home/mseminario2/vestarv/implementations/asic/castalia/analog/data/raw/drive_map__fs3__i_sink.csv" cross((v("/V_OutOL")-v("/V_InP")) 0.05 1 "falling")))
    errset(mtxDump("/home/mseminario2/vestarv/implementations/asic/castalia/analog/data/raw/drive_map__fs3__i_span.csv" (cross((v("/V_OutOL")-v("/V_InP")) -0.05 1 "falling")-cross((v("/V_OutOL")-v("/V_InP")) 0.05 1 "falling"))))
    errset(mtxDump("/home/mseminario2/vestarv/implementations/asic/castalia/analog/data/raw/drive_map__fs3__i_src.csv" cross((v("/V_OutOL")-v("/V_InP")) -0.05 1 "falling")))
    errset(mtxDump("/home/mseminario2/vestarv/implementations/asic/castalia/analog/data/raw/drive_map__fs3__idd_q.csv" value(abs(i("/POWER/SRC_VDD25/PLUS")) 0.0)))
    errset(mtxDump("/home/mseminario2/vestarv/implementations/asic/castalia/analog/data/raw/drive_map__fs3__rout.csv" abs((value(v("/V_OutOL") 0.5e-6)-value(v("/V_OutOL") -0.5e-6))/1e-6)))
    errset(mtxDump("/home/mseminario2/vestarv/implementations/asic/castalia/analog/data/raw/drive_map__fs3__verr.csv" (v("/V_OutOL")-v("/V_InP"))))
    errset(mtxDump("/home/mseminario2/vestarv/implementations/asic/castalia/analog/data/raw/drive_map__fs3__verr_q.csv" value((v("/V_OutOL")-v("/V_InP")) 0.0)))
  )
)

;; ---- corner 4 (sf4) / test drive_map
when(isDir("/home/mseminario2/chips/castalia/simarchive/anatop_tb_controlamp/Interactive.137/4/DriveMapTB/psf")
  openResults("/home/mseminario2/chips/castalia/simarchive/anatop_tb_controlamp/Interactive.137/4/DriveMapTB/psf")
  when(member('dc results())
    selectResult('dc)
    mtxP = outfile("/home/mseminario2/vestarv/implementations/asic/castalia/analog/data/raw/drive_map__sf4.meta" "w")
    fprintf(mtxP "sweep %%L\n" car(errset(sweepNames())))
    close(mtxP)
    errset(mtxDump("/home/mseminario2/vestarv/implementations/asic/castalia/analog/data/raw/drive_map__sf4__i_sink.csv" cross((v("/V_OutOL")-v("/V_InP")) 0.05 1 "falling")))
    errset(mtxDump("/home/mseminario2/vestarv/implementations/asic/castalia/analog/data/raw/drive_map__sf4__i_span.csv" (cross((v("/V_OutOL")-v("/V_InP")) -0.05 1 "falling")-cross((v("/V_OutOL")-v("/V_InP")) 0.05 1 "falling"))))
    errset(mtxDump("/home/mseminario2/vestarv/implementations/asic/castalia/analog/data/raw/drive_map__sf4__i_src.csv" cross((v("/V_OutOL")-v("/V_InP")) -0.05 1 "falling")))
    errset(mtxDump("/home/mseminario2/vestarv/implementations/asic/castalia/analog/data/raw/drive_map__sf4__idd_q.csv" value(abs(i("/POWER/SRC_VDD25/PLUS")) 0.0)))
    errset(mtxDump("/home/mseminario2/vestarv/implementations/asic/castalia/analog/data/raw/drive_map__sf4__rout.csv" abs((value(v("/V_OutOL") 0.5e-6)-value(v("/V_OutOL") -0.5e-6))/1e-6)))
    errset(mtxDump("/home/mseminario2/vestarv/implementations/asic/castalia/analog/data/raw/drive_map__sf4__verr.csv" (v("/V_OutOL")-v("/V_InP"))))
    errset(mtxDump("/home/mseminario2/vestarv/implementations/asic/castalia/analog/data/raw/drive_map__sf4__verr_q.csv" value((v("/V_OutOL")-v("/V_InP")) 0.0)))
  )
)

;; ---- corner 5 (ss5) / test drive_map
when(isDir("/home/mseminario2/chips/castalia/simarchive/anatop_tb_controlamp/Interactive.137/5/DriveMapTB/psf")
  openResults("/home/mseminario2/chips/castalia/simarchive/anatop_tb_controlamp/Interactive.137/5/DriveMapTB/psf")
  when(member('dc results())
    selectResult('dc)
    mtxP = outfile("/home/mseminario2/vestarv/implementations/asic/castalia/analog/data/raw/drive_map__ss5.meta" "w")
    fprintf(mtxP "sweep %%L\n" car(errset(sweepNames())))
    close(mtxP)
    errset(mtxDump("/home/mseminario2/vestarv/implementations/asic/castalia/analog/data/raw/drive_map__ss5__i_sink.csv" cross((v("/V_OutOL")-v("/V_InP")) 0.05 1 "falling")))
    errset(mtxDump("/home/mseminario2/vestarv/implementations/asic/castalia/analog/data/raw/drive_map__ss5__i_span.csv" (cross((v("/V_OutOL")-v("/V_InP")) -0.05 1 "falling")-cross((v("/V_OutOL")-v("/V_InP")) 0.05 1 "falling"))))
    errset(mtxDump("/home/mseminario2/vestarv/implementations/asic/castalia/analog/data/raw/drive_map__ss5__i_src.csv" cross((v("/V_OutOL")-v("/V_InP")) -0.05 1 "falling")))
    errset(mtxDump("/home/mseminario2/vestarv/implementations/asic/castalia/analog/data/raw/drive_map__ss5__idd_q.csv" value(abs(i("/POWER/SRC_VDD25/PLUS")) 0.0)))
    errset(mtxDump("/home/mseminario2/vestarv/implementations/asic/castalia/analog/data/raw/drive_map__ss5__rout.csv" abs((value(v("/V_OutOL") 0.5e-6)-value(v("/V_OutOL") -0.5e-6))/1e-6)))
    errset(mtxDump("/home/mseminario2/vestarv/implementations/asic/castalia/analog/data/raw/drive_map__ss5__verr.csv" (v("/V_OutOL")-v("/V_InP"))))
    errset(mtxDump("/home/mseminario2/vestarv/implementations/asic/castalia/analog/data/raw/drive_map__ss5__verr_q.csv" value((v("/V_OutOL")-v("/V_InP")) 0.0)))
  )
)

;; ---- corner 6 (tt6) / test drive_map
when(isDir("/home/mseminario2/chips/castalia/simarchive/anatop_tb_controlamp/Interactive.137/6/DriveMapTB/psf")
  openResults("/home/mseminario2/chips/castalia/simarchive/anatop_tb_controlamp/Interactive.137/6/DriveMapTB/psf")
  when(member('dc results())
    selectResult('dc)
    mtxP = outfile("/home/mseminario2/vestarv/implementations/asic/castalia/analog/data/raw/drive_map__tt6.meta" "w")
    fprintf(mtxP "sweep %%L\n" car(errset(sweepNames())))
    close(mtxP)
    errset(mtxDump("/home/mseminario2/vestarv/implementations/asic/castalia/analog/data/raw/drive_map__tt6__i_sink.csv" cross((v("/V_OutOL")-v("/V_InP")) 0.05 1 "falling")))
    errset(mtxDump("/home/mseminario2/vestarv/implementations/asic/castalia/analog/data/raw/drive_map__tt6__i_span.csv" (cross((v("/V_OutOL")-v("/V_InP")) -0.05 1 "falling")-cross((v("/V_OutOL")-v("/V_InP")) 0.05 1 "falling"))))
    errset(mtxDump("/home/mseminario2/vestarv/implementations/asic/castalia/analog/data/raw/drive_map__tt6__i_src.csv" cross((v("/V_OutOL")-v("/V_InP")) -0.05 1 "falling")))
    errset(mtxDump("/home/mseminario2/vestarv/implementations/asic/castalia/analog/data/raw/drive_map__tt6__idd_q.csv" value(abs(i("/POWER/SRC_VDD25/PLUS")) 0.0)))
    errset(mtxDump("/home/mseminario2/vestarv/implementations/asic/castalia/analog/data/raw/drive_map__tt6__rout.csv" abs((value(v("/V_OutOL") 0.5e-6)-value(v("/V_OutOL") -0.5e-6))/1e-6)))
    errset(mtxDump("/home/mseminario2/vestarv/implementations/asic/castalia/analog/data/raw/drive_map__tt6__verr.csv" (v("/V_OutOL")-v("/V_InP"))))
    errset(mtxDump("/home/mseminario2/vestarv/implementations/asic/castalia/analog/data/raw/drive_map__tt6__verr_q.csv" value((v("/V_OutOL")-v("/V_InP")) 0.0)))
  )
)

;; ---- corner 7 (ff7) / test drive_map
when(isDir("/home/mseminario2/chips/castalia/simarchive/anatop_tb_controlamp/Interactive.137/7/DriveMapTB/psf")
  openResults("/home/mseminario2/chips/castalia/simarchive/anatop_tb_controlamp/Interactive.137/7/DriveMapTB/psf")
  when(member('dc results())
    selectResult('dc)
    mtxP = outfile("/home/mseminario2/vestarv/implementations/asic/castalia/analog/data/raw/drive_map__ff7.meta" "w")
    fprintf(mtxP "sweep %%L\n" car(errset(sweepNames())))
    close(mtxP)
    errset(mtxDump("/home/mseminario2/vestarv/implementations/asic/castalia/analog/data/raw/drive_map__ff7__i_sink.csv" cross((v("/V_OutOL")-v("/V_InP")) 0.05 1 "falling")))
    errset(mtxDump("/home/mseminario2/vestarv/implementations/asic/castalia/analog/data/raw/drive_map__ff7__i_span.csv" (cross((v("/V_OutOL")-v("/V_InP")) -0.05 1 "falling")-cross((v("/V_OutOL")-v("/V_InP")) 0.05 1 "falling"))))
    errset(mtxDump("/home/mseminario2/vestarv/implementations/asic/castalia/analog/data/raw/drive_map__ff7__i_src.csv" cross((v("/V_OutOL")-v("/V_InP")) -0.05 1 "falling")))
    errset(mtxDump("/home/mseminario2/vestarv/implementations/asic/castalia/analog/data/raw/drive_map__ff7__idd_q.csv" value(abs(i("/POWER/SRC_VDD25/PLUS")) 0.0)))
    errset(mtxDump("/home/mseminario2/vestarv/implementations/asic/castalia/analog/data/raw/drive_map__ff7__rout.csv" abs((value(v("/V_OutOL") 0.5e-6)-value(v("/V_OutOL") -0.5e-6))/1e-6)))
    errset(mtxDump("/home/mseminario2/vestarv/implementations/asic/castalia/analog/data/raw/drive_map__ff7__verr.csv" (v("/V_OutOL")-v("/V_InP"))))
    errset(mtxDump("/home/mseminario2/vestarv/implementations/asic/castalia/analog/data/raw/drive_map__ff7__verr_q.csv" value((v("/V_OutOL")-v("/V_InP")) 0.0)))
  )
)

;; ---- corner 8 (fs8) / test drive_map
when(isDir("/home/mseminario2/chips/castalia/simarchive/anatop_tb_controlamp/Interactive.137/8/DriveMapTB/psf")
  openResults("/home/mseminario2/chips/castalia/simarchive/anatop_tb_controlamp/Interactive.137/8/DriveMapTB/psf")
  when(member('dc results())
    selectResult('dc)
    mtxP = outfile("/home/mseminario2/vestarv/implementations/asic/castalia/analog/data/raw/drive_map__fs8.meta" "w")
    fprintf(mtxP "sweep %%L\n" car(errset(sweepNames())))
    close(mtxP)
    errset(mtxDump("/home/mseminario2/vestarv/implementations/asic/castalia/analog/data/raw/drive_map__fs8__i_sink.csv" cross((v("/V_OutOL")-v("/V_InP")) 0.05 1 "falling")))
    errset(mtxDump("/home/mseminario2/vestarv/implementations/asic/castalia/analog/data/raw/drive_map__fs8__i_span.csv" (cross((v("/V_OutOL")-v("/V_InP")) -0.05 1 "falling")-cross((v("/V_OutOL")-v("/V_InP")) 0.05 1 "falling"))))
    errset(mtxDump("/home/mseminario2/vestarv/implementations/asic/castalia/analog/data/raw/drive_map__fs8__i_src.csv" cross((v("/V_OutOL")-v("/V_InP")) -0.05 1 "falling")))
    errset(mtxDump("/home/mseminario2/vestarv/implementations/asic/castalia/analog/data/raw/drive_map__fs8__idd_q.csv" value(abs(i("/POWER/SRC_VDD25/PLUS")) 0.0)))
    errset(mtxDump("/home/mseminario2/vestarv/implementations/asic/castalia/analog/data/raw/drive_map__fs8__rout.csv" abs((value(v("/V_OutOL") 0.5e-6)-value(v("/V_OutOL") -0.5e-6))/1e-6)))
    errset(mtxDump("/home/mseminario2/vestarv/implementations/asic/castalia/analog/data/raw/drive_map__fs8__verr.csv" (v("/V_OutOL")-v("/V_InP"))))
    errset(mtxDump("/home/mseminario2/vestarv/implementations/asic/castalia/analog/data/raw/drive_map__fs8__verr_q.csv" value((v("/V_OutOL")-v("/V_InP")) 0.0)))
  )
)

;; ---- corner 9 (sf9) / test drive_map
when(isDir("/home/mseminario2/chips/castalia/simarchive/anatop_tb_controlamp/Interactive.137/9/DriveMapTB/psf")
  openResults("/home/mseminario2/chips/castalia/simarchive/anatop_tb_controlamp/Interactive.137/9/DriveMapTB/psf")
  when(member('dc results())
    selectResult('dc)
    mtxP = outfile("/home/mseminario2/vestarv/implementations/asic/castalia/analog/data/raw/drive_map__sf9.meta" "w")
    fprintf(mtxP "sweep %%L\n" car(errset(sweepNames())))
    close(mtxP)
    errset(mtxDump("/home/mseminario2/vestarv/implementations/asic/castalia/analog/data/raw/drive_map__sf9__i_sink.csv" cross((v("/V_OutOL")-v("/V_InP")) 0.05 1 "falling")))
    errset(mtxDump("/home/mseminario2/vestarv/implementations/asic/castalia/analog/data/raw/drive_map__sf9__i_span.csv" (cross((v("/V_OutOL")-v("/V_InP")) -0.05 1 "falling")-cross((v("/V_OutOL")-v("/V_InP")) 0.05 1 "falling"))))
    errset(mtxDump("/home/mseminario2/vestarv/implementations/asic/castalia/analog/data/raw/drive_map__sf9__i_src.csv" cross((v("/V_OutOL")-v("/V_InP")) -0.05 1 "falling")))
    errset(mtxDump("/home/mseminario2/vestarv/implementations/asic/castalia/analog/data/raw/drive_map__sf9__idd_q.csv" value(abs(i("/POWER/SRC_VDD25/PLUS")) 0.0)))
    errset(mtxDump("/home/mseminario2/vestarv/implementations/asic/castalia/analog/data/raw/drive_map__sf9__rout.csv" abs((value(v("/V_OutOL") 0.5e-6)-value(v("/V_OutOL") -0.5e-6))/1e-6)))
    errset(mtxDump("/home/mseminario2/vestarv/implementations/asic/castalia/analog/data/raw/drive_map__sf9__verr.csv" (v("/V_OutOL")-v("/V_InP"))))
    errset(mtxDump("/home/mseminario2/vestarv/implementations/asic/castalia/analog/data/raw/drive_map__sf9__verr_q.csv" value((v("/V_OutOL")-v("/V_InP")) 0.0)))
  )
)

;; ---- corner 10 (ss10) / test drive_map
when(isDir("/home/mseminario2/chips/castalia/simarchive/anatop_tb_controlamp/Interactive.137/10/DriveMapTB/psf")
  openResults("/home/mseminario2/chips/castalia/simarchive/anatop_tb_controlamp/Interactive.137/10/DriveMapTB/psf")
  when(member('dc results())
    selectResult('dc)
    mtxP = outfile("/home/mseminario2/vestarv/implementations/asic/castalia/analog/data/raw/drive_map__ss10.meta" "w")
    fprintf(mtxP "sweep %%L\n" car(errset(sweepNames())))
    close(mtxP)
    errset(mtxDump("/home/mseminario2/vestarv/implementations/asic/castalia/analog/data/raw/drive_map__ss10__i_sink.csv" cross((v("/V_OutOL")-v("/V_InP")) 0.05 1 "falling")))
    errset(mtxDump("/home/mseminario2/vestarv/implementations/asic/castalia/analog/data/raw/drive_map__ss10__i_span.csv" (cross((v("/V_OutOL")-v("/V_InP")) -0.05 1 "falling")-cross((v("/V_OutOL")-v("/V_InP")) 0.05 1 "falling"))))
    errset(mtxDump("/home/mseminario2/vestarv/implementations/asic/castalia/analog/data/raw/drive_map__ss10__i_src.csv" cross((v("/V_OutOL")-v("/V_InP")) -0.05 1 "falling")))
    errset(mtxDump("/home/mseminario2/vestarv/implementations/asic/castalia/analog/data/raw/drive_map__ss10__idd_q.csv" value(abs(i("/POWER/SRC_VDD25/PLUS")) 0.0)))
    errset(mtxDump("/home/mseminario2/vestarv/implementations/asic/castalia/analog/data/raw/drive_map__ss10__rout.csv" abs((value(v("/V_OutOL") 0.5e-6)-value(v("/V_OutOL") -0.5e-6))/1e-6)))
    errset(mtxDump("/home/mseminario2/vestarv/implementations/asic/castalia/analog/data/raw/drive_map__ss10__verr.csv" (v("/V_OutOL")-v("/V_InP"))))
    errset(mtxDump("/home/mseminario2/vestarv/implementations/asic/castalia/analog/data/raw/drive_map__ss10__verr_q.csv" value((v("/V_OutOL")-v("/V_InP")) 0.0)))
  )
)

;; ---- corner 11 (tt11) / test drive_map
when(isDir("/home/mseminario2/chips/castalia/simarchive/anatop_tb_controlamp/Interactive.137/11/DriveMapTB/psf")
  openResults("/home/mseminario2/chips/castalia/simarchive/anatop_tb_controlamp/Interactive.137/11/DriveMapTB/psf")
  when(member('dc results())
    selectResult('dc)
    mtxP = outfile("/home/mseminario2/vestarv/implementations/asic/castalia/analog/data/raw/drive_map__tt11.meta" "w")
    fprintf(mtxP "sweep %%L\n" car(errset(sweepNames())))
    close(mtxP)
    errset(mtxDump("/home/mseminario2/vestarv/implementations/asic/castalia/analog/data/raw/drive_map__tt11__i_sink.csv" cross((v("/V_OutOL")-v("/V_InP")) 0.05 1 "falling")))
    errset(mtxDump("/home/mseminario2/vestarv/implementations/asic/castalia/analog/data/raw/drive_map__tt11__i_span.csv" (cross((v("/V_OutOL")-v("/V_InP")) -0.05 1 "falling")-cross((v("/V_OutOL")-v("/V_InP")) 0.05 1 "falling"))))
    errset(mtxDump("/home/mseminario2/vestarv/implementations/asic/castalia/analog/data/raw/drive_map__tt11__i_src.csv" cross((v("/V_OutOL")-v("/V_InP")) -0.05 1 "falling")))
    errset(mtxDump("/home/mseminario2/vestarv/implementations/asic/castalia/analog/data/raw/drive_map__tt11__idd_q.csv" value(abs(i("/POWER/SRC_VDD25/PLUS")) 0.0)))
    errset(mtxDump("/home/mseminario2/vestarv/implementations/asic/castalia/analog/data/raw/drive_map__tt11__rout.csv" abs((value(v("/V_OutOL") 0.5e-6)-value(v("/V_OutOL") -0.5e-6))/1e-6)))
    errset(mtxDump("/home/mseminario2/vestarv/implementations/asic/castalia/analog/data/raw/drive_map__tt11__verr.csv" (v("/V_OutOL")-v("/V_InP"))))
    errset(mtxDump("/home/mseminario2/vestarv/implementations/asic/castalia/analog/data/raw/drive_map__tt11__verr_q.csv" value((v("/V_OutOL")-v("/V_InP")) 0.0)))
  )
)

;; ---- corner 12 (ff12) / test drive_map
when(isDir("/home/mseminario2/chips/castalia/simarchive/anatop_tb_controlamp/Interactive.137/12/DriveMapTB/psf")
  openResults("/home/mseminario2/chips/castalia/simarchive/anatop_tb_controlamp/Interactive.137/12/DriveMapTB/psf")
  when(member('dc results())
    selectResult('dc)
    mtxP = outfile("/home/mseminario2/vestarv/implementations/asic/castalia/analog/data/raw/drive_map__ff12.meta" "w")
    fprintf(mtxP "sweep %%L\n" car(errset(sweepNames())))
    close(mtxP)
    errset(mtxDump("/home/mseminario2/vestarv/implementations/asic/castalia/analog/data/raw/drive_map__ff12__i_sink.csv" cross((v("/V_OutOL")-v("/V_InP")) 0.05 1 "falling")))
    errset(mtxDump("/home/mseminario2/vestarv/implementations/asic/castalia/analog/data/raw/drive_map__ff12__i_span.csv" (cross((v("/V_OutOL")-v("/V_InP")) -0.05 1 "falling")-cross((v("/V_OutOL")-v("/V_InP")) 0.05 1 "falling"))))
    errset(mtxDump("/home/mseminario2/vestarv/implementations/asic/castalia/analog/data/raw/drive_map__ff12__i_src.csv" cross((v("/V_OutOL")-v("/V_InP")) -0.05 1 "falling")))
    errset(mtxDump("/home/mseminario2/vestarv/implementations/asic/castalia/analog/data/raw/drive_map__ff12__idd_q.csv" value(abs(i("/POWER/SRC_VDD25/PLUS")) 0.0)))
    errset(mtxDump("/home/mseminario2/vestarv/implementations/asic/castalia/analog/data/raw/drive_map__ff12__rout.csv" abs((value(v("/V_OutOL") 0.5e-6)-value(v("/V_OutOL") -0.5e-6))/1e-6)))
    errset(mtxDump("/home/mseminario2/vestarv/implementations/asic/castalia/analog/data/raw/drive_map__ff12__verr.csv" (v("/V_OutOL")-v("/V_InP"))))
    errset(mtxDump("/home/mseminario2/vestarv/implementations/asic/castalia/analog/data/raw/drive_map__ff12__verr_q.csv" value((v("/V_OutOL")-v("/V_InP")) 0.0)))
  )
)

;; ---- corner 13 (fs13) / test drive_map
when(isDir("/home/mseminario2/chips/castalia/simarchive/anatop_tb_controlamp/Interactive.137/13/DriveMapTB/psf")
  openResults("/home/mseminario2/chips/castalia/simarchive/anatop_tb_controlamp/Interactive.137/13/DriveMapTB/psf")
  when(member('dc results())
    selectResult('dc)
    mtxP = outfile("/home/mseminario2/vestarv/implementations/asic/castalia/analog/data/raw/drive_map__fs13.meta" "w")
    fprintf(mtxP "sweep %%L\n" car(errset(sweepNames())))
    close(mtxP)
    errset(mtxDump("/home/mseminario2/vestarv/implementations/asic/castalia/analog/data/raw/drive_map__fs13__i_sink.csv" cross((v("/V_OutOL")-v("/V_InP")) 0.05 1 "falling")))
    errset(mtxDump("/home/mseminario2/vestarv/implementations/asic/castalia/analog/data/raw/drive_map__fs13__i_span.csv" (cross((v("/V_OutOL")-v("/V_InP")) -0.05 1 "falling")-cross((v("/V_OutOL")-v("/V_InP")) 0.05 1 "falling"))))
    errset(mtxDump("/home/mseminario2/vestarv/implementations/asic/castalia/analog/data/raw/drive_map__fs13__i_src.csv" cross((v("/V_OutOL")-v("/V_InP")) -0.05 1 "falling")))
    errset(mtxDump("/home/mseminario2/vestarv/implementations/asic/castalia/analog/data/raw/drive_map__fs13__idd_q.csv" value(abs(i("/POWER/SRC_VDD25/PLUS")) 0.0)))
    errset(mtxDump("/home/mseminario2/vestarv/implementations/asic/castalia/analog/data/raw/drive_map__fs13__rout.csv" abs((value(v("/V_OutOL") 0.5e-6)-value(v("/V_OutOL") -0.5e-6))/1e-6)))
    errset(mtxDump("/home/mseminario2/vestarv/implementations/asic/castalia/analog/data/raw/drive_map__fs13__verr.csv" (v("/V_OutOL")-v("/V_InP"))))
    errset(mtxDump("/home/mseminario2/vestarv/implementations/asic/castalia/analog/data/raw/drive_map__fs13__verr_q.csv" value((v("/V_OutOL")-v("/V_InP")) 0.0)))
  )
)

;; ---- corner 14 (sf14) / test drive_map
when(isDir("/home/mseminario2/chips/castalia/simarchive/anatop_tb_controlamp/Interactive.137/14/DriveMapTB/psf")
  openResults("/home/mseminario2/chips/castalia/simarchive/anatop_tb_controlamp/Interactive.137/14/DriveMapTB/psf")
  when(member('dc results())
    selectResult('dc)
    mtxP = outfile("/home/mseminario2/vestarv/implementations/asic/castalia/analog/data/raw/drive_map__sf14.meta" "w")
    fprintf(mtxP "sweep %%L\n" car(errset(sweepNames())))
    close(mtxP)
    errset(mtxDump("/home/mseminario2/vestarv/implementations/asic/castalia/analog/data/raw/drive_map__sf14__i_sink.csv" cross((v("/V_OutOL")-v("/V_InP")) 0.05 1 "falling")))
    errset(mtxDump("/home/mseminario2/vestarv/implementations/asic/castalia/analog/data/raw/drive_map__sf14__i_span.csv" (cross((v("/V_OutOL")-v("/V_InP")) -0.05 1 "falling")-cross((v("/V_OutOL")-v("/V_InP")) 0.05 1 "falling"))))
    errset(mtxDump("/home/mseminario2/vestarv/implementations/asic/castalia/analog/data/raw/drive_map__sf14__i_src.csv" cross((v("/V_OutOL")-v("/V_InP")) -0.05 1 "falling")))
    errset(mtxDump("/home/mseminario2/vestarv/implementations/asic/castalia/analog/data/raw/drive_map__sf14__idd_q.csv" value(abs(i("/POWER/SRC_VDD25/PLUS")) 0.0)))
    errset(mtxDump("/home/mseminario2/vestarv/implementations/asic/castalia/analog/data/raw/drive_map__sf14__rout.csv" abs((value(v("/V_OutOL") 0.5e-6)-value(v("/V_OutOL") -0.5e-6))/1e-6)))
    errset(mtxDump("/home/mseminario2/vestarv/implementations/asic/castalia/analog/data/raw/drive_map__sf14__verr.csv" (v("/V_OutOL")-v("/V_InP"))))
    errset(mtxDump("/home/mseminario2/vestarv/implementations/asic/castalia/analog/data/raw/drive_map__sf14__verr_q.csv" value((v("/V_OutOL")-v("/V_InP")) 0.0)))
  )
)

;; ---- corner 15 (ss15) / test drive_map
when(isDir("/home/mseminario2/chips/castalia/simarchive/anatop_tb_controlamp/Interactive.137/15/DriveMapTB/psf")
  openResults("/home/mseminario2/chips/castalia/simarchive/anatop_tb_controlamp/Interactive.137/15/DriveMapTB/psf")
  when(member('dc results())
    selectResult('dc)
    mtxP = outfile("/home/mseminario2/vestarv/implementations/asic/castalia/analog/data/raw/drive_map__ss15.meta" "w")
    fprintf(mtxP "sweep %%L\n" car(errset(sweepNames())))
    close(mtxP)
    errset(mtxDump("/home/mseminario2/vestarv/implementations/asic/castalia/analog/data/raw/drive_map__ss15__i_sink.csv" cross((v("/V_OutOL")-v("/V_InP")) 0.05 1 "falling")))
    errset(mtxDump("/home/mseminario2/vestarv/implementations/asic/castalia/analog/data/raw/drive_map__ss15__i_span.csv" (cross((v("/V_OutOL")-v("/V_InP")) -0.05 1 "falling")-cross((v("/V_OutOL")-v("/V_InP")) 0.05 1 "falling"))))
    errset(mtxDump("/home/mseminario2/vestarv/implementations/asic/castalia/analog/data/raw/drive_map__ss15__i_src.csv" cross((v("/V_OutOL")-v("/V_InP")) -0.05 1 "falling")))
    errset(mtxDump("/home/mseminario2/vestarv/implementations/asic/castalia/analog/data/raw/drive_map__ss15__idd_q.csv" value(abs(i("/POWER/SRC_VDD25/PLUS")) 0.0)))
    errset(mtxDump("/home/mseminario2/vestarv/implementations/asic/castalia/analog/data/raw/drive_map__ss15__rout.csv" abs((value(v("/V_OutOL") 0.5e-6)-value(v("/V_OutOL") -0.5e-6))/1e-6)))
    errset(mtxDump("/home/mseminario2/vestarv/implementations/asic/castalia/analog/data/raw/drive_map__ss15__verr.csv" (v("/V_OutOL")-v("/V_InP"))))
    errset(mtxDump("/home/mseminario2/vestarv/implementations/asic/castalia/analog/data/raw/drive_map__ss15__verr_q.csv" value((v("/V_OutOL")-v("/V_InP")) 0.0)))
  )
)

;; ---- corner 16 (tt16) / test drive_map
when(isDir("/home/mseminario2/chips/castalia/simarchive/anatop_tb_controlamp/Interactive.137/16/DriveMapTB/psf")
  openResults("/home/mseminario2/chips/castalia/simarchive/anatop_tb_controlamp/Interactive.137/16/DriveMapTB/psf")
  when(member('dc results())
    selectResult('dc)
    mtxP = outfile("/home/mseminario2/vestarv/implementations/asic/castalia/analog/data/raw/drive_map__tt16.meta" "w")
    fprintf(mtxP "sweep %%L\n" car(errset(sweepNames())))
    close(mtxP)
    errset(mtxDump("/home/mseminario2/vestarv/implementations/asic/castalia/analog/data/raw/drive_map__tt16__i_sink.csv" cross((v("/V_OutOL")-v("/V_InP")) 0.05 1 "falling")))
    errset(mtxDump("/home/mseminario2/vestarv/implementations/asic/castalia/analog/data/raw/drive_map__tt16__i_span.csv" (cross((v("/V_OutOL")-v("/V_InP")) -0.05 1 "falling")-cross((v("/V_OutOL")-v("/V_InP")) 0.05 1 "falling"))))
    errset(mtxDump("/home/mseminario2/vestarv/implementations/asic/castalia/analog/data/raw/drive_map__tt16__i_src.csv" cross((v("/V_OutOL")-v("/V_InP")) -0.05 1 "falling")))
    errset(mtxDump("/home/mseminario2/vestarv/implementations/asic/castalia/analog/data/raw/drive_map__tt16__idd_q.csv" value(abs(i("/POWER/SRC_VDD25/PLUS")) 0.0)))
    errset(mtxDump("/home/mseminario2/vestarv/implementations/asic/castalia/analog/data/raw/drive_map__tt16__rout.csv" abs((value(v("/V_OutOL") 0.5e-6)-value(v("/V_OutOL") -0.5e-6))/1e-6)))
    errset(mtxDump("/home/mseminario2/vestarv/implementations/asic/castalia/analog/data/raw/drive_map__tt16__verr.csv" (v("/V_OutOL")-v("/V_InP"))))
    errset(mtxDump("/home/mseminario2/vestarv/implementations/asic/castalia/analog/data/raw/drive_map__tt16__verr_q.csv" value((v("/V_OutOL")-v("/V_InP")) 0.0)))
  )
)

;; ---- corner 17 (ff17) / test drive_map
when(isDir("/home/mseminario2/chips/castalia/simarchive/anatop_tb_controlamp/Interactive.137/17/DriveMapTB/psf")
  openResults("/home/mseminario2/chips/castalia/simarchive/anatop_tb_controlamp/Interactive.137/17/DriveMapTB/psf")
  when(member('dc results())
    selectResult('dc)
    mtxP = outfile("/home/mseminario2/vestarv/implementations/asic/castalia/analog/data/raw/drive_map__ff17.meta" "w")
    fprintf(mtxP "sweep %%L\n" car(errset(sweepNames())))
    close(mtxP)
    errset(mtxDump("/home/mseminario2/vestarv/implementations/asic/castalia/analog/data/raw/drive_map__ff17__i_sink.csv" cross((v("/V_OutOL")-v("/V_InP")) 0.05 1 "falling")))
    errset(mtxDump("/home/mseminario2/vestarv/implementations/asic/castalia/analog/data/raw/drive_map__ff17__i_span.csv" (cross((v("/V_OutOL")-v("/V_InP")) -0.05 1 "falling")-cross((v("/V_OutOL")-v("/V_InP")) 0.05 1 "falling"))))
    errset(mtxDump("/home/mseminario2/vestarv/implementations/asic/castalia/analog/data/raw/drive_map__ff17__i_src.csv" cross((v("/V_OutOL")-v("/V_InP")) -0.05 1 "falling")))
    errset(mtxDump("/home/mseminario2/vestarv/implementations/asic/castalia/analog/data/raw/drive_map__ff17__idd_q.csv" value(abs(i("/POWER/SRC_VDD25/PLUS")) 0.0)))
    errset(mtxDump("/home/mseminario2/vestarv/implementations/asic/castalia/analog/data/raw/drive_map__ff17__rout.csv" abs((value(v("/V_OutOL") 0.5e-6)-value(v("/V_OutOL") -0.5e-6))/1e-6)))
    errset(mtxDump("/home/mseminario2/vestarv/implementations/asic/castalia/analog/data/raw/drive_map__ff17__verr.csv" (v("/V_OutOL")-v("/V_InP"))))
    errset(mtxDump("/home/mseminario2/vestarv/implementations/asic/castalia/analog/data/raw/drive_map__ff17__verr_q.csv" value((v("/V_OutOL")-v("/V_InP")) 0.0)))
  )
)

;; ---- corner 18 (fs18) / test drive_map
when(isDir("/home/mseminario2/chips/castalia/simarchive/anatop_tb_controlamp/Interactive.137/18/DriveMapTB/psf")
  openResults("/home/mseminario2/chips/castalia/simarchive/anatop_tb_controlamp/Interactive.137/18/DriveMapTB/psf")
  when(member('dc results())
    selectResult('dc)
    mtxP = outfile("/home/mseminario2/vestarv/implementations/asic/castalia/analog/data/raw/drive_map__fs18.meta" "w")
    fprintf(mtxP "sweep %%L\n" car(errset(sweepNames())))
    close(mtxP)
    errset(mtxDump("/home/mseminario2/vestarv/implementations/asic/castalia/analog/data/raw/drive_map__fs18__i_sink.csv" cross((v("/V_OutOL")-v("/V_InP")) 0.05 1 "falling")))
    errset(mtxDump("/home/mseminario2/vestarv/implementations/asic/castalia/analog/data/raw/drive_map__fs18__i_span.csv" (cross((v("/V_OutOL")-v("/V_InP")) -0.05 1 "falling")-cross((v("/V_OutOL")-v("/V_InP")) 0.05 1 "falling"))))
    errset(mtxDump("/home/mseminario2/vestarv/implementations/asic/castalia/analog/data/raw/drive_map__fs18__i_src.csv" cross((v("/V_OutOL")-v("/V_InP")) -0.05 1 "falling")))
    errset(mtxDump("/home/mseminario2/vestarv/implementations/asic/castalia/analog/data/raw/drive_map__fs18__idd_q.csv" value(abs(i("/POWER/SRC_VDD25/PLUS")) 0.0)))
    errset(mtxDump("/home/mseminario2/vestarv/implementations/asic/castalia/analog/data/raw/drive_map__fs18__rout.csv" abs((value(v("/V_OutOL") 0.5e-6)-value(v("/V_OutOL") -0.5e-6))/1e-6)))
    errset(mtxDump("/home/mseminario2/vestarv/implementations/asic/castalia/analog/data/raw/drive_map__fs18__verr.csv" (v("/V_OutOL")-v("/V_InP"))))
    errset(mtxDump("/home/mseminario2/vestarv/implementations/asic/castalia/analog/data/raw/drive_map__fs18__verr_q.csv" value((v("/V_OutOL")-v("/V_InP")) 0.0)))
  )
)

;; ---- corner 19 (sf19) / test drive_map
when(isDir("/home/mseminario2/chips/castalia/simarchive/anatop_tb_controlamp/Interactive.137/19/DriveMapTB/psf")
  openResults("/home/mseminario2/chips/castalia/simarchive/anatop_tb_controlamp/Interactive.137/19/DriveMapTB/psf")
  when(member('dc results())
    selectResult('dc)
    mtxP = outfile("/home/mseminario2/vestarv/implementations/asic/castalia/analog/data/raw/drive_map__sf19.meta" "w")
    fprintf(mtxP "sweep %%L\n" car(errset(sweepNames())))
    close(mtxP)
    errset(mtxDump("/home/mseminario2/vestarv/implementations/asic/castalia/analog/data/raw/drive_map__sf19__i_sink.csv" cross((v("/V_OutOL")-v("/V_InP")) 0.05 1 "falling")))
    errset(mtxDump("/home/mseminario2/vestarv/implementations/asic/castalia/analog/data/raw/drive_map__sf19__i_span.csv" (cross((v("/V_OutOL")-v("/V_InP")) -0.05 1 "falling")-cross((v("/V_OutOL")-v("/V_InP")) 0.05 1 "falling"))))
    errset(mtxDump("/home/mseminario2/vestarv/implementations/asic/castalia/analog/data/raw/drive_map__sf19__i_src.csv" cross((v("/V_OutOL")-v("/V_InP")) -0.05 1 "falling")))
    errset(mtxDump("/home/mseminario2/vestarv/implementations/asic/castalia/analog/data/raw/drive_map__sf19__idd_q.csv" value(abs(i("/POWER/SRC_VDD25/PLUS")) 0.0)))
    errset(mtxDump("/home/mseminario2/vestarv/implementations/asic/castalia/analog/data/raw/drive_map__sf19__rout.csv" abs((value(v("/V_OutOL") 0.5e-6)-value(v("/V_OutOL") -0.5e-6))/1e-6)))
    errset(mtxDump("/home/mseminario2/vestarv/implementations/asic/castalia/analog/data/raw/drive_map__sf19__verr.csv" (v("/V_OutOL")-v("/V_InP"))))
    errset(mtxDump("/home/mseminario2/vestarv/implementations/asic/castalia/analog/data/raw/drive_map__sf19__verr_q.csv" value((v("/V_OutOL")-v("/V_InP")) 0.0)))
  )
)

;; ---- corner 20 (ss20) / test drive_map
when(isDir("/home/mseminario2/chips/castalia/simarchive/anatop_tb_controlamp/Interactive.137/20/DriveMapTB/psf")
  openResults("/home/mseminario2/chips/castalia/simarchive/anatop_tb_controlamp/Interactive.137/20/DriveMapTB/psf")
  when(member('dc results())
    selectResult('dc)
    mtxP = outfile("/home/mseminario2/vestarv/implementations/asic/castalia/analog/data/raw/drive_map__ss20.meta" "w")
    fprintf(mtxP "sweep %%L\n" car(errset(sweepNames())))
    close(mtxP)
    errset(mtxDump("/home/mseminario2/vestarv/implementations/asic/castalia/analog/data/raw/drive_map__ss20__i_sink.csv" cross((v("/V_OutOL")-v("/V_InP")) 0.05 1 "falling")))
    errset(mtxDump("/home/mseminario2/vestarv/implementations/asic/castalia/analog/data/raw/drive_map__ss20__i_span.csv" (cross((v("/V_OutOL")-v("/V_InP")) -0.05 1 "falling")-cross((v("/V_OutOL")-v("/V_InP")) 0.05 1 "falling"))))
    errset(mtxDump("/home/mseminario2/vestarv/implementations/asic/castalia/analog/data/raw/drive_map__ss20__i_src.csv" cross((v("/V_OutOL")-v("/V_InP")) -0.05 1 "falling")))
    errset(mtxDump("/home/mseminario2/vestarv/implementations/asic/castalia/analog/data/raw/drive_map__ss20__idd_q.csv" value(abs(i("/POWER/SRC_VDD25/PLUS")) 0.0)))
    errset(mtxDump("/home/mseminario2/vestarv/implementations/asic/castalia/analog/data/raw/drive_map__ss20__rout.csv" abs((value(v("/V_OutOL") 0.5e-6)-value(v("/V_OutOL") -0.5e-6))/1e-6)))
    errset(mtxDump("/home/mseminario2/vestarv/implementations/asic/castalia/analog/data/raw/drive_map__ss20__verr.csv" (v("/V_OutOL")-v("/V_InP"))))
    errset(mtxDump("/home/mseminario2/vestarv/implementations/asic/castalia/analog/data/raw/drive_map__ss20__verr_q.csv" value((v("/V_OutOL")-v("/V_InP")) 0.0)))
  )
)

;; ---- corner 21 (tt21) / test drive_map
when(isDir("/home/mseminario2/chips/castalia/simarchive/anatop_tb_controlamp/Interactive.137/21/DriveMapTB/psf")
  openResults("/home/mseminario2/chips/castalia/simarchive/anatop_tb_controlamp/Interactive.137/21/DriveMapTB/psf")
  when(member('dc results())
    selectResult('dc)
    mtxP = outfile("/home/mseminario2/vestarv/implementations/asic/castalia/analog/data/raw/drive_map__tt21.meta" "w")
    fprintf(mtxP "sweep %%L\n" car(errset(sweepNames())))
    close(mtxP)
    errset(mtxDump("/home/mseminario2/vestarv/implementations/asic/castalia/analog/data/raw/drive_map__tt21__i_sink.csv" cross((v("/V_OutOL")-v("/V_InP")) 0.05 1 "falling")))
    errset(mtxDump("/home/mseminario2/vestarv/implementations/asic/castalia/analog/data/raw/drive_map__tt21__i_span.csv" (cross((v("/V_OutOL")-v("/V_InP")) -0.05 1 "falling")-cross((v("/V_OutOL")-v("/V_InP")) 0.05 1 "falling"))))
    errset(mtxDump("/home/mseminario2/vestarv/implementations/asic/castalia/analog/data/raw/drive_map__tt21__i_src.csv" cross((v("/V_OutOL")-v("/V_InP")) -0.05 1 "falling")))
    errset(mtxDump("/home/mseminario2/vestarv/implementations/asic/castalia/analog/data/raw/drive_map__tt21__idd_q.csv" value(abs(i("/POWER/SRC_VDD25/PLUS")) 0.0)))
    errset(mtxDump("/home/mseminario2/vestarv/implementations/asic/castalia/analog/data/raw/drive_map__tt21__rout.csv" abs((value(v("/V_OutOL") 0.5e-6)-value(v("/V_OutOL") -0.5e-6))/1e-6)))
    errset(mtxDump("/home/mseminario2/vestarv/implementations/asic/castalia/analog/data/raw/drive_map__tt21__verr.csv" (v("/V_OutOL")-v("/V_InP"))))
    errset(mtxDump("/home/mseminario2/vestarv/implementations/asic/castalia/analog/data/raw/drive_map__tt21__verr_q.csv" value((v("/V_OutOL")-v("/V_InP")) 0.0)))
  )
)

;; ---- corner 22 (ff22) / test drive_map
when(isDir("/home/mseminario2/chips/castalia/simarchive/anatop_tb_controlamp/Interactive.137/22/DriveMapTB/psf")
  openResults("/home/mseminario2/chips/castalia/simarchive/anatop_tb_controlamp/Interactive.137/22/DriveMapTB/psf")
  when(member('dc results())
    selectResult('dc)
    mtxP = outfile("/home/mseminario2/vestarv/implementations/asic/castalia/analog/data/raw/drive_map__ff22.meta" "w")
    fprintf(mtxP "sweep %%L\n" car(errset(sweepNames())))
    close(mtxP)
    errset(mtxDump("/home/mseminario2/vestarv/implementations/asic/castalia/analog/data/raw/drive_map__ff22__i_sink.csv" cross((v("/V_OutOL")-v("/V_InP")) 0.05 1 "falling")))
    errset(mtxDump("/home/mseminario2/vestarv/implementations/asic/castalia/analog/data/raw/drive_map__ff22__i_span.csv" (cross((v("/V_OutOL")-v("/V_InP")) -0.05 1 "falling")-cross((v("/V_OutOL")-v("/V_InP")) 0.05 1 "falling"))))
    errset(mtxDump("/home/mseminario2/vestarv/implementations/asic/castalia/analog/data/raw/drive_map__ff22__i_src.csv" cross((v("/V_OutOL")-v("/V_InP")) -0.05 1 "falling")))
    errset(mtxDump("/home/mseminario2/vestarv/implementations/asic/castalia/analog/data/raw/drive_map__ff22__idd_q.csv" value(abs(i("/POWER/SRC_VDD25/PLUS")) 0.0)))
    errset(mtxDump("/home/mseminario2/vestarv/implementations/asic/castalia/analog/data/raw/drive_map__ff22__rout.csv" abs((value(v("/V_OutOL") 0.5e-6)-value(v("/V_OutOL") -0.5e-6))/1e-6)))
    errset(mtxDump("/home/mseminario2/vestarv/implementations/asic/castalia/analog/data/raw/drive_map__ff22__verr.csv" (v("/V_OutOL")-v("/V_InP"))))
    errset(mtxDump("/home/mseminario2/vestarv/implementations/asic/castalia/analog/data/raw/drive_map__ff22__verr_q.csv" value((v("/V_OutOL")-v("/V_InP")) 0.0)))
  )
)

;; ---- corner 23 (fs23) / test drive_map
when(isDir("/home/mseminario2/chips/castalia/simarchive/anatop_tb_controlamp/Interactive.137/23/DriveMapTB/psf")
  openResults("/home/mseminario2/chips/castalia/simarchive/anatop_tb_controlamp/Interactive.137/23/DriveMapTB/psf")
  when(member('dc results())
    selectResult('dc)
    mtxP = outfile("/home/mseminario2/vestarv/implementations/asic/castalia/analog/data/raw/drive_map__fs23.meta" "w")
    fprintf(mtxP "sweep %%L\n" car(errset(sweepNames())))
    close(mtxP)
    errset(mtxDump("/home/mseminario2/vestarv/implementations/asic/castalia/analog/data/raw/drive_map__fs23__i_sink.csv" cross((v("/V_OutOL")-v("/V_InP")) 0.05 1 "falling")))
    errset(mtxDump("/home/mseminario2/vestarv/implementations/asic/castalia/analog/data/raw/drive_map__fs23__i_span.csv" (cross((v("/V_OutOL")-v("/V_InP")) -0.05 1 "falling")-cross((v("/V_OutOL")-v("/V_InP")) 0.05 1 "falling"))))
    errset(mtxDump("/home/mseminario2/vestarv/implementations/asic/castalia/analog/data/raw/drive_map__fs23__i_src.csv" cross((v("/V_OutOL")-v("/V_InP")) -0.05 1 "falling")))
    errset(mtxDump("/home/mseminario2/vestarv/implementations/asic/castalia/analog/data/raw/drive_map__fs23__idd_q.csv" value(abs(i("/POWER/SRC_VDD25/PLUS")) 0.0)))
    errset(mtxDump("/home/mseminario2/vestarv/implementations/asic/castalia/analog/data/raw/drive_map__fs23__rout.csv" abs((value(v("/V_OutOL") 0.5e-6)-value(v("/V_OutOL") -0.5e-6))/1e-6)))
    errset(mtxDump("/home/mseminario2/vestarv/implementations/asic/castalia/analog/data/raw/drive_map__fs23__verr.csv" (v("/V_OutOL")-v("/V_InP"))))
    errset(mtxDump("/home/mseminario2/vestarv/implementations/asic/castalia/analog/data/raw/drive_map__fs23__verr_q.csv" value((v("/V_OutOL")-v("/V_InP")) 0.0)))
  )
)

;; ---- corner 24 (sf24) / test drive_map
when(isDir("/home/mseminario2/chips/castalia/simarchive/anatop_tb_controlamp/Interactive.137/24/DriveMapTB/psf")
  openResults("/home/mseminario2/chips/castalia/simarchive/anatop_tb_controlamp/Interactive.137/24/DriveMapTB/psf")
  when(member('dc results())
    selectResult('dc)
    mtxP = outfile("/home/mseminario2/vestarv/implementations/asic/castalia/analog/data/raw/drive_map__sf24.meta" "w")
    fprintf(mtxP "sweep %%L\n" car(errset(sweepNames())))
    close(mtxP)
    errset(mtxDump("/home/mseminario2/vestarv/implementations/asic/castalia/analog/data/raw/drive_map__sf24__i_sink.csv" cross((v("/V_OutOL")-v("/V_InP")) 0.05 1 "falling")))
    errset(mtxDump("/home/mseminario2/vestarv/implementations/asic/castalia/analog/data/raw/drive_map__sf24__i_span.csv" (cross((v("/V_OutOL")-v("/V_InP")) -0.05 1 "falling")-cross((v("/V_OutOL")-v("/V_InP")) 0.05 1 "falling"))))
    errset(mtxDump("/home/mseminario2/vestarv/implementations/asic/castalia/analog/data/raw/drive_map__sf24__i_src.csv" cross((v("/V_OutOL")-v("/V_InP")) -0.05 1 "falling")))
    errset(mtxDump("/home/mseminario2/vestarv/implementations/asic/castalia/analog/data/raw/drive_map__sf24__idd_q.csv" value(abs(i("/POWER/SRC_VDD25/PLUS")) 0.0)))
    errset(mtxDump("/home/mseminario2/vestarv/implementations/asic/castalia/analog/data/raw/drive_map__sf24__rout.csv" abs((value(v("/V_OutOL") 0.5e-6)-value(v("/V_OutOL") -0.5e-6))/1e-6)))
    errset(mtxDump("/home/mseminario2/vestarv/implementations/asic/castalia/analog/data/raw/drive_map__sf24__verr.csv" (v("/V_OutOL")-v("/V_InP"))))
    errset(mtxDump("/home/mseminario2/vestarv/implementations/asic/castalia/analog/data/raw/drive_map__sf24__verr_q.csv" value((v("/V_OutOL")-v("/V_InP")) 0.0)))
  )
)

;; ---- corner 25 (ss25) / test drive_map
when(isDir("/home/mseminario2/chips/castalia/simarchive/anatop_tb_controlamp/Interactive.137/25/DriveMapTB/psf")
  openResults("/home/mseminario2/chips/castalia/simarchive/anatop_tb_controlamp/Interactive.137/25/DriveMapTB/psf")
  when(member('dc results())
    selectResult('dc)
    mtxP = outfile("/home/mseminario2/vestarv/implementations/asic/castalia/analog/data/raw/drive_map__ss25.meta" "w")
    fprintf(mtxP "sweep %%L\n" car(errset(sweepNames())))
    close(mtxP)
    errset(mtxDump("/home/mseminario2/vestarv/implementations/asic/castalia/analog/data/raw/drive_map__ss25__i_sink.csv" cross((v("/V_OutOL")-v("/V_InP")) 0.05 1 "falling")))
    errset(mtxDump("/home/mseminario2/vestarv/implementations/asic/castalia/analog/data/raw/drive_map__ss25__i_span.csv" (cross((v("/V_OutOL")-v("/V_InP")) -0.05 1 "falling")-cross((v("/V_OutOL")-v("/V_InP")) 0.05 1 "falling"))))
    errset(mtxDump("/home/mseminario2/vestarv/implementations/asic/castalia/analog/data/raw/drive_map__ss25__i_src.csv" cross((v("/V_OutOL")-v("/V_InP")) -0.05 1 "falling")))
    errset(mtxDump("/home/mseminario2/vestarv/implementations/asic/castalia/analog/data/raw/drive_map__ss25__idd_q.csv" value(abs(i("/POWER/SRC_VDD25/PLUS")) 0.0)))
    errset(mtxDump("/home/mseminario2/vestarv/implementations/asic/castalia/analog/data/raw/drive_map__ss25__rout.csv" abs((value(v("/V_OutOL") 0.5e-6)-value(v("/V_OutOL") -0.5e-6))/1e-6)))
    errset(mtxDump("/home/mseminario2/vestarv/implementations/asic/castalia/analog/data/raw/drive_map__ss25__verr.csv" (v("/V_OutOL")-v("/V_InP"))))
    errset(mtxDump("/home/mseminario2/vestarv/implementations/asic/castalia/analog/data/raw/drive_map__ss25__verr_q.csv" value((v("/V_OutOL")-v("/V_InP")) 0.0)))
  )
)

;; ---- corner 26 (tt26) / test drive_map
when(isDir("/home/mseminario2/chips/castalia/simarchive/anatop_tb_controlamp/Interactive.137/26/DriveMapTB/psf")
  openResults("/home/mseminario2/chips/castalia/simarchive/anatop_tb_controlamp/Interactive.137/26/DriveMapTB/psf")
  when(member('dc results())
    selectResult('dc)
    mtxP = outfile("/home/mseminario2/vestarv/implementations/asic/castalia/analog/data/raw/drive_map__tt26.meta" "w")
    fprintf(mtxP "sweep %%L\n" car(errset(sweepNames())))
    close(mtxP)
    errset(mtxDump("/home/mseminario2/vestarv/implementations/asic/castalia/analog/data/raw/drive_map__tt26__i_sink.csv" cross((v("/V_OutOL")-v("/V_InP")) 0.05 1 "falling")))
    errset(mtxDump("/home/mseminario2/vestarv/implementations/asic/castalia/analog/data/raw/drive_map__tt26__i_span.csv" (cross((v("/V_OutOL")-v("/V_InP")) -0.05 1 "falling")-cross((v("/V_OutOL")-v("/V_InP")) 0.05 1 "falling"))))
    errset(mtxDump("/home/mseminario2/vestarv/implementations/asic/castalia/analog/data/raw/drive_map__tt26__i_src.csv" cross((v("/V_OutOL")-v("/V_InP")) -0.05 1 "falling")))
    errset(mtxDump("/home/mseminario2/vestarv/implementations/asic/castalia/analog/data/raw/drive_map__tt26__idd_q.csv" value(abs(i("/POWER/SRC_VDD25/PLUS")) 0.0)))
    errset(mtxDump("/home/mseminario2/vestarv/implementations/asic/castalia/analog/data/raw/drive_map__tt26__rout.csv" abs((value(v("/V_OutOL") 0.5e-6)-value(v("/V_OutOL") -0.5e-6))/1e-6)))
    errset(mtxDump("/home/mseminario2/vestarv/implementations/asic/castalia/analog/data/raw/drive_map__tt26__verr.csv" (v("/V_OutOL")-v("/V_InP"))))
    errset(mtxDump("/home/mseminario2/vestarv/implementations/asic/castalia/analog/data/raw/drive_map__tt26__verr_q.csv" value((v("/V_OutOL")-v("/V_InP")) 0.0)))
  )
)

;; ---- corner 27 (ff27) / test drive_map
when(isDir("/home/mseminario2/chips/castalia/simarchive/anatop_tb_controlamp/Interactive.137/27/DriveMapTB/psf")
  openResults("/home/mseminario2/chips/castalia/simarchive/anatop_tb_controlamp/Interactive.137/27/DriveMapTB/psf")
  when(member('dc results())
    selectResult('dc)
    mtxP = outfile("/home/mseminario2/vestarv/implementations/asic/castalia/analog/data/raw/drive_map__ff27.meta" "w")
    fprintf(mtxP "sweep %%L\n" car(errset(sweepNames())))
    close(mtxP)
    errset(mtxDump("/home/mseminario2/vestarv/implementations/asic/castalia/analog/data/raw/drive_map__ff27__i_sink.csv" cross((v("/V_OutOL")-v("/V_InP")) 0.05 1 "falling")))
    errset(mtxDump("/home/mseminario2/vestarv/implementations/asic/castalia/analog/data/raw/drive_map__ff27__i_span.csv" (cross((v("/V_OutOL")-v("/V_InP")) -0.05 1 "falling")-cross((v("/V_OutOL")-v("/V_InP")) 0.05 1 "falling"))))
    errset(mtxDump("/home/mseminario2/vestarv/implementations/asic/castalia/analog/data/raw/drive_map__ff27__i_src.csv" cross((v("/V_OutOL")-v("/V_InP")) -0.05 1 "falling")))
    errset(mtxDump("/home/mseminario2/vestarv/implementations/asic/castalia/analog/data/raw/drive_map__ff27__idd_q.csv" value(abs(i("/POWER/SRC_VDD25/PLUS")) 0.0)))
    errset(mtxDump("/home/mseminario2/vestarv/implementations/asic/castalia/analog/data/raw/drive_map__ff27__rout.csv" abs((value(v("/V_OutOL") 0.5e-6)-value(v("/V_OutOL") -0.5e-6))/1e-6)))
    errset(mtxDump("/home/mseminario2/vestarv/implementations/asic/castalia/analog/data/raw/drive_map__ff27__verr.csv" (v("/V_OutOL")-v("/V_InP"))))
    errset(mtxDump("/home/mseminario2/vestarv/implementations/asic/castalia/analog/data/raw/drive_map__ff27__verr_q.csv" value((v("/V_OutOL")-v("/V_InP")) 0.0)))
  )
)

;; ---- corner 28 (fs28) / test drive_map
when(isDir("/home/mseminario2/chips/castalia/simarchive/anatop_tb_controlamp/Interactive.137/28/DriveMapTB/psf")
  openResults("/home/mseminario2/chips/castalia/simarchive/anatop_tb_controlamp/Interactive.137/28/DriveMapTB/psf")
  when(member('dc results())
    selectResult('dc)
    mtxP = outfile("/home/mseminario2/vestarv/implementations/asic/castalia/analog/data/raw/drive_map__fs28.meta" "w")
    fprintf(mtxP "sweep %%L\n" car(errset(sweepNames())))
    close(mtxP)
    errset(mtxDump("/home/mseminario2/vestarv/implementations/asic/castalia/analog/data/raw/drive_map__fs28__i_sink.csv" cross((v("/V_OutOL")-v("/V_InP")) 0.05 1 "falling")))
    errset(mtxDump("/home/mseminario2/vestarv/implementations/asic/castalia/analog/data/raw/drive_map__fs28__i_span.csv" (cross((v("/V_OutOL")-v("/V_InP")) -0.05 1 "falling")-cross((v("/V_OutOL")-v("/V_InP")) 0.05 1 "falling"))))
    errset(mtxDump("/home/mseminario2/vestarv/implementations/asic/castalia/analog/data/raw/drive_map__fs28__i_src.csv" cross((v("/V_OutOL")-v("/V_InP")) -0.05 1 "falling")))
    errset(mtxDump("/home/mseminario2/vestarv/implementations/asic/castalia/analog/data/raw/drive_map__fs28__idd_q.csv" value(abs(i("/POWER/SRC_VDD25/PLUS")) 0.0)))
    errset(mtxDump("/home/mseminario2/vestarv/implementations/asic/castalia/analog/data/raw/drive_map__fs28__rout.csv" abs((value(v("/V_OutOL") 0.5e-6)-value(v("/V_OutOL") -0.5e-6))/1e-6)))
    errset(mtxDump("/home/mseminario2/vestarv/implementations/asic/castalia/analog/data/raw/drive_map__fs28__verr.csv" (v("/V_OutOL")-v("/V_InP"))))
    errset(mtxDump("/home/mseminario2/vestarv/implementations/asic/castalia/analog/data/raw/drive_map__fs28__verr_q.csv" value((v("/V_OutOL")-v("/V_InP")) 0.0)))
  )
)

;; ---- corner 29 (sf29) / test drive_map
when(isDir("/home/mseminario2/chips/castalia/simarchive/anatop_tb_controlamp/Interactive.137/29/DriveMapTB/psf")
  openResults("/home/mseminario2/chips/castalia/simarchive/anatop_tb_controlamp/Interactive.137/29/DriveMapTB/psf")
  when(member('dc results())
    selectResult('dc)
    mtxP = outfile("/home/mseminario2/vestarv/implementations/asic/castalia/analog/data/raw/drive_map__sf29.meta" "w")
    fprintf(mtxP "sweep %%L\n" car(errset(sweepNames())))
    close(mtxP)
    errset(mtxDump("/home/mseminario2/vestarv/implementations/asic/castalia/analog/data/raw/drive_map__sf29__i_sink.csv" cross((v("/V_OutOL")-v("/V_InP")) 0.05 1 "falling")))
    errset(mtxDump("/home/mseminario2/vestarv/implementations/asic/castalia/analog/data/raw/drive_map__sf29__i_span.csv" (cross((v("/V_OutOL")-v("/V_InP")) -0.05 1 "falling")-cross((v("/V_OutOL")-v("/V_InP")) 0.05 1 "falling"))))
    errset(mtxDump("/home/mseminario2/vestarv/implementations/asic/castalia/analog/data/raw/drive_map__sf29__i_src.csv" cross((v("/V_OutOL")-v("/V_InP")) -0.05 1 "falling")))
    errset(mtxDump("/home/mseminario2/vestarv/implementations/asic/castalia/analog/data/raw/drive_map__sf29__idd_q.csv" value(abs(i("/POWER/SRC_VDD25/PLUS")) 0.0)))
    errset(mtxDump("/home/mseminario2/vestarv/implementations/asic/castalia/analog/data/raw/drive_map__sf29__rout.csv" abs((value(v("/V_OutOL") 0.5e-6)-value(v("/V_OutOL") -0.5e-6))/1e-6)))
    errset(mtxDump("/home/mseminario2/vestarv/implementations/asic/castalia/analog/data/raw/drive_map__sf29__verr.csv" (v("/V_OutOL")-v("/V_InP"))))
    errset(mtxDump("/home/mseminario2/vestarv/implementations/asic/castalia/analog/data/raw/drive_map__sf29__verr_q.csv" value((v("/V_OutOL")-v("/V_InP")) 0.0)))
  )
)

;; ---- corner 30 (ss30) / test drive_map
when(isDir("/home/mseminario2/chips/castalia/simarchive/anatop_tb_controlamp/Interactive.137/30/DriveMapTB/psf")
  openResults("/home/mseminario2/chips/castalia/simarchive/anatop_tb_controlamp/Interactive.137/30/DriveMapTB/psf")
  when(member('dc results())
    selectResult('dc)
    mtxP = outfile("/home/mseminario2/vestarv/implementations/asic/castalia/analog/data/raw/drive_map__ss30.meta" "w")
    fprintf(mtxP "sweep %%L\n" car(errset(sweepNames())))
    close(mtxP)
    errset(mtxDump("/home/mseminario2/vestarv/implementations/asic/castalia/analog/data/raw/drive_map__ss30__i_sink.csv" cross((v("/V_OutOL")-v("/V_InP")) 0.05 1 "falling")))
    errset(mtxDump("/home/mseminario2/vestarv/implementations/asic/castalia/analog/data/raw/drive_map__ss30__i_span.csv" (cross((v("/V_OutOL")-v("/V_InP")) -0.05 1 "falling")-cross((v("/V_OutOL")-v("/V_InP")) 0.05 1 "falling"))))
    errset(mtxDump("/home/mseminario2/vestarv/implementations/asic/castalia/analog/data/raw/drive_map__ss30__i_src.csv" cross((v("/V_OutOL")-v("/V_InP")) -0.05 1 "falling")))
    errset(mtxDump("/home/mseminario2/vestarv/implementations/asic/castalia/analog/data/raw/drive_map__ss30__idd_q.csv" value(abs(i("/POWER/SRC_VDD25/PLUS")) 0.0)))
    errset(mtxDump("/home/mseminario2/vestarv/implementations/asic/castalia/analog/data/raw/drive_map__ss30__rout.csv" abs((value(v("/V_OutOL") 0.5e-6)-value(v("/V_OutOL") -0.5e-6))/1e-6)))
    errset(mtxDump("/home/mseminario2/vestarv/implementations/asic/castalia/analog/data/raw/drive_map__ss30__verr.csv" (v("/V_OutOL")-v("/V_InP"))))
    errset(mtxDump("/home/mseminario2/vestarv/implementations/asic/castalia/analog/data/raw/drive_map__ss30__verr_q.csv" value((v("/V_OutOL")-v("/V_InP")) 0.0)))
  )
)

;; ---- corner 31 (tt31) / test drive_map
when(isDir("/home/mseminario2/chips/castalia/simarchive/anatop_tb_controlamp/Interactive.137/31/DriveMapTB/psf")
  openResults("/home/mseminario2/chips/castalia/simarchive/anatop_tb_controlamp/Interactive.137/31/DriveMapTB/psf")
  when(member('dc results())
    selectResult('dc)
    mtxP = outfile("/home/mseminario2/vestarv/implementations/asic/castalia/analog/data/raw/drive_map__tt31.meta" "w")
    fprintf(mtxP "sweep %%L\n" car(errset(sweepNames())))
    close(mtxP)
    errset(mtxDump("/home/mseminario2/vestarv/implementations/asic/castalia/analog/data/raw/drive_map__tt31__i_sink.csv" cross((v("/V_OutOL")-v("/V_InP")) 0.05 1 "falling")))
    errset(mtxDump("/home/mseminario2/vestarv/implementations/asic/castalia/analog/data/raw/drive_map__tt31__i_span.csv" (cross((v("/V_OutOL")-v("/V_InP")) -0.05 1 "falling")-cross((v("/V_OutOL")-v("/V_InP")) 0.05 1 "falling"))))
    errset(mtxDump("/home/mseminario2/vestarv/implementations/asic/castalia/analog/data/raw/drive_map__tt31__i_src.csv" cross((v("/V_OutOL")-v("/V_InP")) -0.05 1 "falling")))
    errset(mtxDump("/home/mseminario2/vestarv/implementations/asic/castalia/analog/data/raw/drive_map__tt31__idd_q.csv" value(abs(i("/POWER/SRC_VDD25/PLUS")) 0.0)))
    errset(mtxDump("/home/mseminario2/vestarv/implementations/asic/castalia/analog/data/raw/drive_map__tt31__rout.csv" abs((value(v("/V_OutOL") 0.5e-6)-value(v("/V_OutOL") -0.5e-6))/1e-6)))
    errset(mtxDump("/home/mseminario2/vestarv/implementations/asic/castalia/analog/data/raw/drive_map__tt31__verr.csv" (v("/V_OutOL")-v("/V_InP"))))
    errset(mtxDump("/home/mseminario2/vestarv/implementations/asic/castalia/analog/data/raw/drive_map__tt31__verr_q.csv" value((v("/V_OutOL")-v("/V_InP")) 0.0)))
  )
)

;; ---- corner 32 (ff32) / test drive_map
when(isDir("/home/mseminario2/chips/castalia/simarchive/anatop_tb_controlamp/Interactive.137/32/DriveMapTB/psf")
  openResults("/home/mseminario2/chips/castalia/simarchive/anatop_tb_controlamp/Interactive.137/32/DriveMapTB/psf")
  when(member('dc results())
    selectResult('dc)
    mtxP = outfile("/home/mseminario2/vestarv/implementations/asic/castalia/analog/data/raw/drive_map__ff32.meta" "w")
    fprintf(mtxP "sweep %%L\n" car(errset(sweepNames())))
    close(mtxP)
    errset(mtxDump("/home/mseminario2/vestarv/implementations/asic/castalia/analog/data/raw/drive_map__ff32__i_sink.csv" cross((v("/V_OutOL")-v("/V_InP")) 0.05 1 "falling")))
    errset(mtxDump("/home/mseminario2/vestarv/implementations/asic/castalia/analog/data/raw/drive_map__ff32__i_span.csv" (cross((v("/V_OutOL")-v("/V_InP")) -0.05 1 "falling")-cross((v("/V_OutOL")-v("/V_InP")) 0.05 1 "falling"))))
    errset(mtxDump("/home/mseminario2/vestarv/implementations/asic/castalia/analog/data/raw/drive_map__ff32__i_src.csv" cross((v("/V_OutOL")-v("/V_InP")) -0.05 1 "falling")))
    errset(mtxDump("/home/mseminario2/vestarv/implementations/asic/castalia/analog/data/raw/drive_map__ff32__idd_q.csv" value(abs(i("/POWER/SRC_VDD25/PLUS")) 0.0)))
    errset(mtxDump("/home/mseminario2/vestarv/implementations/asic/castalia/analog/data/raw/drive_map__ff32__rout.csv" abs((value(v("/V_OutOL") 0.5e-6)-value(v("/V_OutOL") -0.5e-6))/1e-6)))
    errset(mtxDump("/home/mseminario2/vestarv/implementations/asic/castalia/analog/data/raw/drive_map__ff32__verr.csv" (v("/V_OutOL")-v("/V_InP"))))
    errset(mtxDump("/home/mseminario2/vestarv/implementations/asic/castalia/analog/data/raw/drive_map__ff32__verr_q.csv" value((v("/V_OutOL")-v("/V_InP")) 0.0)))
  )
)

;; ---- corner 33 (fs33) / test drive_map
when(isDir("/home/mseminario2/chips/castalia/simarchive/anatop_tb_controlamp/Interactive.137/33/DriveMapTB/psf")
  openResults("/home/mseminario2/chips/castalia/simarchive/anatop_tb_controlamp/Interactive.137/33/DriveMapTB/psf")
  when(member('dc results())
    selectResult('dc)
    mtxP = outfile("/home/mseminario2/vestarv/implementations/asic/castalia/analog/data/raw/drive_map__fs33.meta" "w")
    fprintf(mtxP "sweep %%L\n" car(errset(sweepNames())))
    close(mtxP)
    errset(mtxDump("/home/mseminario2/vestarv/implementations/asic/castalia/analog/data/raw/drive_map__fs33__i_sink.csv" cross((v("/V_OutOL")-v("/V_InP")) 0.05 1 "falling")))
    errset(mtxDump("/home/mseminario2/vestarv/implementations/asic/castalia/analog/data/raw/drive_map__fs33__i_span.csv" (cross((v("/V_OutOL")-v("/V_InP")) -0.05 1 "falling")-cross((v("/V_OutOL")-v("/V_InP")) 0.05 1 "falling"))))
    errset(mtxDump("/home/mseminario2/vestarv/implementations/asic/castalia/analog/data/raw/drive_map__fs33__i_src.csv" cross((v("/V_OutOL")-v("/V_InP")) -0.05 1 "falling")))
    errset(mtxDump("/home/mseminario2/vestarv/implementations/asic/castalia/analog/data/raw/drive_map__fs33__idd_q.csv" value(abs(i("/POWER/SRC_VDD25/PLUS")) 0.0)))
    errset(mtxDump("/home/mseminario2/vestarv/implementations/asic/castalia/analog/data/raw/drive_map__fs33__rout.csv" abs((value(v("/V_OutOL") 0.5e-6)-value(v("/V_OutOL") -0.5e-6))/1e-6)))
    errset(mtxDump("/home/mseminario2/vestarv/implementations/asic/castalia/analog/data/raw/drive_map__fs33__verr.csv" (v("/V_OutOL")-v("/V_InP"))))
    errset(mtxDump("/home/mseminario2/vestarv/implementations/asic/castalia/analog/data/raw/drive_map__fs33__verr_q.csv" value((v("/V_OutOL")-v("/V_InP")) 0.0)))
  )
)

;; ---- corner 34 (sf34) / test drive_map
when(isDir("/home/mseminario2/chips/castalia/simarchive/anatop_tb_controlamp/Interactive.137/34/DriveMapTB/psf")
  openResults("/home/mseminario2/chips/castalia/simarchive/anatop_tb_controlamp/Interactive.137/34/DriveMapTB/psf")
  when(member('dc results())
    selectResult('dc)
    mtxP = outfile("/home/mseminario2/vestarv/implementations/asic/castalia/analog/data/raw/drive_map__sf34.meta" "w")
    fprintf(mtxP "sweep %%L\n" car(errset(sweepNames())))
    close(mtxP)
    errset(mtxDump("/home/mseminario2/vestarv/implementations/asic/castalia/analog/data/raw/drive_map__sf34__i_sink.csv" cross((v("/V_OutOL")-v("/V_InP")) 0.05 1 "falling")))
    errset(mtxDump("/home/mseminario2/vestarv/implementations/asic/castalia/analog/data/raw/drive_map__sf34__i_span.csv" (cross((v("/V_OutOL")-v("/V_InP")) -0.05 1 "falling")-cross((v("/V_OutOL")-v("/V_InP")) 0.05 1 "falling"))))
    errset(mtxDump("/home/mseminario2/vestarv/implementations/asic/castalia/analog/data/raw/drive_map__sf34__i_src.csv" cross((v("/V_OutOL")-v("/V_InP")) -0.05 1 "falling")))
    errset(mtxDump("/home/mseminario2/vestarv/implementations/asic/castalia/analog/data/raw/drive_map__sf34__idd_q.csv" value(abs(i("/POWER/SRC_VDD25/PLUS")) 0.0)))
    errset(mtxDump("/home/mseminario2/vestarv/implementations/asic/castalia/analog/data/raw/drive_map__sf34__rout.csv" abs((value(v("/V_OutOL") 0.5e-6)-value(v("/V_OutOL") -0.5e-6))/1e-6)))
    errset(mtxDump("/home/mseminario2/vestarv/implementations/asic/castalia/analog/data/raw/drive_map__sf34__verr.csv" (v("/V_OutOL")-v("/V_InP"))))
    errset(mtxDump("/home/mseminario2/vestarv/implementations/asic/castalia/analog/data/raw/drive_map__sf34__verr_q.csv" value((v("/V_OutOL")-v("/V_InP")) 0.0)))
  )
)

;; ---- corner 35 (ss35) / test drive_map
when(isDir("/home/mseminario2/chips/castalia/simarchive/anatop_tb_controlamp/Interactive.137/35/DriveMapTB/psf")
  openResults("/home/mseminario2/chips/castalia/simarchive/anatop_tb_controlamp/Interactive.137/35/DriveMapTB/psf")
  when(member('dc results())
    selectResult('dc)
    mtxP = outfile("/home/mseminario2/vestarv/implementations/asic/castalia/analog/data/raw/drive_map__ss35.meta" "w")
    fprintf(mtxP "sweep %%L\n" car(errset(sweepNames())))
    close(mtxP)
    errset(mtxDump("/home/mseminario2/vestarv/implementations/asic/castalia/analog/data/raw/drive_map__ss35__i_sink.csv" cross((v("/V_OutOL")-v("/V_InP")) 0.05 1 "falling")))
    errset(mtxDump("/home/mseminario2/vestarv/implementations/asic/castalia/analog/data/raw/drive_map__ss35__i_span.csv" (cross((v("/V_OutOL")-v("/V_InP")) -0.05 1 "falling")-cross((v("/V_OutOL")-v("/V_InP")) 0.05 1 "falling"))))
    errset(mtxDump("/home/mseminario2/vestarv/implementations/asic/castalia/analog/data/raw/drive_map__ss35__i_src.csv" cross((v("/V_OutOL")-v("/V_InP")) -0.05 1 "falling")))
    errset(mtxDump("/home/mseminario2/vestarv/implementations/asic/castalia/analog/data/raw/drive_map__ss35__idd_q.csv" value(abs(i("/POWER/SRC_VDD25/PLUS")) 0.0)))
    errset(mtxDump("/home/mseminario2/vestarv/implementations/asic/castalia/analog/data/raw/drive_map__ss35__rout.csv" abs((value(v("/V_OutOL") 0.5e-6)-value(v("/V_OutOL") -0.5e-6))/1e-6)))
    errset(mtxDump("/home/mseminario2/vestarv/implementations/asic/castalia/analog/data/raw/drive_map__ss35__verr.csv" (v("/V_OutOL")-v("/V_InP"))))
    errset(mtxDump("/home/mseminario2/vestarv/implementations/asic/castalia/analog/data/raw/drive_map__ss35__verr_q.csv" value((v("/V_OutOL")-v("/V_InP")) 0.0)))
  )
)

;; ---- corner 36 (tt36) / test drive_map
when(isDir("/home/mseminario2/chips/castalia/simarchive/anatop_tb_controlamp/Interactive.137/36/DriveMapTB/psf")
  openResults("/home/mseminario2/chips/castalia/simarchive/anatop_tb_controlamp/Interactive.137/36/DriveMapTB/psf")
  when(member('dc results())
    selectResult('dc)
    mtxP = outfile("/home/mseminario2/vestarv/implementations/asic/castalia/analog/data/raw/drive_map__tt36.meta" "w")
    fprintf(mtxP "sweep %%L\n" car(errset(sweepNames())))
    close(mtxP)
    errset(mtxDump("/home/mseminario2/vestarv/implementations/asic/castalia/analog/data/raw/drive_map__tt36__i_sink.csv" cross((v("/V_OutOL")-v("/V_InP")) 0.05 1 "falling")))
    errset(mtxDump("/home/mseminario2/vestarv/implementations/asic/castalia/analog/data/raw/drive_map__tt36__i_span.csv" (cross((v("/V_OutOL")-v("/V_InP")) -0.05 1 "falling")-cross((v("/V_OutOL")-v("/V_InP")) 0.05 1 "falling"))))
    errset(mtxDump("/home/mseminario2/vestarv/implementations/asic/castalia/analog/data/raw/drive_map__tt36__i_src.csv" cross((v("/V_OutOL")-v("/V_InP")) -0.05 1 "falling")))
    errset(mtxDump("/home/mseminario2/vestarv/implementations/asic/castalia/analog/data/raw/drive_map__tt36__idd_q.csv" value(abs(i("/POWER/SRC_VDD25/PLUS")) 0.0)))
    errset(mtxDump("/home/mseminario2/vestarv/implementations/asic/castalia/analog/data/raw/drive_map__tt36__rout.csv" abs((value(v("/V_OutOL") 0.5e-6)-value(v("/V_OutOL") -0.5e-6))/1e-6)))
    errset(mtxDump("/home/mseminario2/vestarv/implementations/asic/castalia/analog/data/raw/drive_map__tt36__verr.csv" (v("/V_OutOL")-v("/V_InP"))))
    errset(mtxDump("/home/mseminario2/vestarv/implementations/asic/castalia/analog/data/raw/drive_map__tt36__verr_q.csv" value((v("/V_OutOL")-v("/V_InP")) 0.0)))
  )
)

;; ---- corner 37 (ff37) / test drive_map
when(isDir("/home/mseminario2/chips/castalia/simarchive/anatop_tb_controlamp/Interactive.137/37/DriveMapTB/psf")
  openResults("/home/mseminario2/chips/castalia/simarchive/anatop_tb_controlamp/Interactive.137/37/DriveMapTB/psf")
  when(member('dc results())
    selectResult('dc)
    mtxP = outfile("/home/mseminario2/vestarv/implementations/asic/castalia/analog/data/raw/drive_map__ff37.meta" "w")
    fprintf(mtxP "sweep %%L\n" car(errset(sweepNames())))
    close(mtxP)
    errset(mtxDump("/home/mseminario2/vestarv/implementations/asic/castalia/analog/data/raw/drive_map__ff37__i_sink.csv" cross((v("/V_OutOL")-v("/V_InP")) 0.05 1 "falling")))
    errset(mtxDump("/home/mseminario2/vestarv/implementations/asic/castalia/analog/data/raw/drive_map__ff37__i_span.csv" (cross((v("/V_OutOL")-v("/V_InP")) -0.05 1 "falling")-cross((v("/V_OutOL")-v("/V_InP")) 0.05 1 "falling"))))
    errset(mtxDump("/home/mseminario2/vestarv/implementations/asic/castalia/analog/data/raw/drive_map__ff37__i_src.csv" cross((v("/V_OutOL")-v("/V_InP")) -0.05 1 "falling")))
    errset(mtxDump("/home/mseminario2/vestarv/implementations/asic/castalia/analog/data/raw/drive_map__ff37__idd_q.csv" value(abs(i("/POWER/SRC_VDD25/PLUS")) 0.0)))
    errset(mtxDump("/home/mseminario2/vestarv/implementations/asic/castalia/analog/data/raw/drive_map__ff37__rout.csv" abs((value(v("/V_OutOL") 0.5e-6)-value(v("/V_OutOL") -0.5e-6))/1e-6)))
    errset(mtxDump("/home/mseminario2/vestarv/implementations/asic/castalia/analog/data/raw/drive_map__ff37__verr.csv" (v("/V_OutOL")-v("/V_InP"))))
    errset(mtxDump("/home/mseminario2/vestarv/implementations/asic/castalia/analog/data/raw/drive_map__ff37__verr_q.csv" value((v("/V_OutOL")-v("/V_InP")) 0.0)))
  )
)

;; ---- corner 38 (fs38) / test drive_map
when(isDir("/home/mseminario2/chips/castalia/simarchive/anatop_tb_controlamp/Interactive.137/38/DriveMapTB/psf")
  openResults("/home/mseminario2/chips/castalia/simarchive/anatop_tb_controlamp/Interactive.137/38/DriveMapTB/psf")
  when(member('dc results())
    selectResult('dc)
    mtxP = outfile("/home/mseminario2/vestarv/implementations/asic/castalia/analog/data/raw/drive_map__fs38.meta" "w")
    fprintf(mtxP "sweep %%L\n" car(errset(sweepNames())))
    close(mtxP)
    errset(mtxDump("/home/mseminario2/vestarv/implementations/asic/castalia/analog/data/raw/drive_map__fs38__i_sink.csv" cross((v("/V_OutOL")-v("/V_InP")) 0.05 1 "falling")))
    errset(mtxDump("/home/mseminario2/vestarv/implementations/asic/castalia/analog/data/raw/drive_map__fs38__i_span.csv" (cross((v("/V_OutOL")-v("/V_InP")) -0.05 1 "falling")-cross((v("/V_OutOL")-v("/V_InP")) 0.05 1 "falling"))))
    errset(mtxDump("/home/mseminario2/vestarv/implementations/asic/castalia/analog/data/raw/drive_map__fs38__i_src.csv" cross((v("/V_OutOL")-v("/V_InP")) -0.05 1 "falling")))
    errset(mtxDump("/home/mseminario2/vestarv/implementations/asic/castalia/analog/data/raw/drive_map__fs38__idd_q.csv" value(abs(i("/POWER/SRC_VDD25/PLUS")) 0.0)))
    errset(mtxDump("/home/mseminario2/vestarv/implementations/asic/castalia/analog/data/raw/drive_map__fs38__rout.csv" abs((value(v("/V_OutOL") 0.5e-6)-value(v("/V_OutOL") -0.5e-6))/1e-6)))
    errset(mtxDump("/home/mseminario2/vestarv/implementations/asic/castalia/analog/data/raw/drive_map__fs38__verr.csv" (v("/V_OutOL")-v("/V_InP"))))
    errset(mtxDump("/home/mseminario2/vestarv/implementations/asic/castalia/analog/data/raw/drive_map__fs38__verr_q.csv" value((v("/V_OutOL")-v("/V_InP")) 0.0)))
  )
)

;; ---- corner 39 (sf39) / test drive_map
when(isDir("/home/mseminario2/chips/castalia/simarchive/anatop_tb_controlamp/Interactive.137/39/DriveMapTB/psf")
  openResults("/home/mseminario2/chips/castalia/simarchive/anatop_tb_controlamp/Interactive.137/39/DriveMapTB/psf")
  when(member('dc results())
    selectResult('dc)
    mtxP = outfile("/home/mseminario2/vestarv/implementations/asic/castalia/analog/data/raw/drive_map__sf39.meta" "w")
    fprintf(mtxP "sweep %%L\n" car(errset(sweepNames())))
    close(mtxP)
    errset(mtxDump("/home/mseminario2/vestarv/implementations/asic/castalia/analog/data/raw/drive_map__sf39__i_sink.csv" cross((v("/V_OutOL")-v("/V_InP")) 0.05 1 "falling")))
    errset(mtxDump("/home/mseminario2/vestarv/implementations/asic/castalia/analog/data/raw/drive_map__sf39__i_span.csv" (cross((v("/V_OutOL")-v("/V_InP")) -0.05 1 "falling")-cross((v("/V_OutOL")-v("/V_InP")) 0.05 1 "falling"))))
    errset(mtxDump("/home/mseminario2/vestarv/implementations/asic/castalia/analog/data/raw/drive_map__sf39__i_src.csv" cross((v("/V_OutOL")-v("/V_InP")) -0.05 1 "falling")))
    errset(mtxDump("/home/mseminario2/vestarv/implementations/asic/castalia/analog/data/raw/drive_map__sf39__idd_q.csv" value(abs(i("/POWER/SRC_VDD25/PLUS")) 0.0)))
    errset(mtxDump("/home/mseminario2/vestarv/implementations/asic/castalia/analog/data/raw/drive_map__sf39__rout.csv" abs((value(v("/V_OutOL") 0.5e-6)-value(v("/V_OutOL") -0.5e-6))/1e-6)))
    errset(mtxDump("/home/mseminario2/vestarv/implementations/asic/castalia/analog/data/raw/drive_map__sf39__verr.csv" (v("/V_OutOL")-v("/V_InP"))))
    errset(mtxDump("/home/mseminario2/vestarv/implementations/asic/castalia/analog/data/raw/drive_map__sf39__verr_q.csv" value((v("/V_OutOL")-v("/V_InP")) 0.0)))
  )
)

;; ---- corner 40 (ss40) / test drive_map
when(isDir("/home/mseminario2/chips/castalia/simarchive/anatop_tb_controlamp/Interactive.137/40/DriveMapTB/psf")
  openResults("/home/mseminario2/chips/castalia/simarchive/anatop_tb_controlamp/Interactive.137/40/DriveMapTB/psf")
  when(member('dc results())
    selectResult('dc)
    mtxP = outfile("/home/mseminario2/vestarv/implementations/asic/castalia/analog/data/raw/drive_map__ss40.meta" "w")
    fprintf(mtxP "sweep %%L\n" car(errset(sweepNames())))
    close(mtxP)
    errset(mtxDump("/home/mseminario2/vestarv/implementations/asic/castalia/analog/data/raw/drive_map__ss40__i_sink.csv" cross((v("/V_OutOL")-v("/V_InP")) 0.05 1 "falling")))
    errset(mtxDump("/home/mseminario2/vestarv/implementations/asic/castalia/analog/data/raw/drive_map__ss40__i_span.csv" (cross((v("/V_OutOL")-v("/V_InP")) -0.05 1 "falling")-cross((v("/V_OutOL")-v("/V_InP")) 0.05 1 "falling"))))
    errset(mtxDump("/home/mseminario2/vestarv/implementations/asic/castalia/analog/data/raw/drive_map__ss40__i_src.csv" cross((v("/V_OutOL")-v("/V_InP")) -0.05 1 "falling")))
    errset(mtxDump("/home/mseminario2/vestarv/implementations/asic/castalia/analog/data/raw/drive_map__ss40__idd_q.csv" value(abs(i("/POWER/SRC_VDD25/PLUS")) 0.0)))
    errset(mtxDump("/home/mseminario2/vestarv/implementations/asic/castalia/analog/data/raw/drive_map__ss40__rout.csv" abs((value(v("/V_OutOL") 0.5e-6)-value(v("/V_OutOL") -0.5e-6))/1e-6)))
    errset(mtxDump("/home/mseminario2/vestarv/implementations/asic/castalia/analog/data/raw/drive_map__ss40__verr.csv" (v("/V_OutOL")-v("/V_InP"))))
    errset(mtxDump("/home/mseminario2/vestarv/implementations/asic/castalia/analog/data/raw/drive_map__ss40__verr_q.csv" value((v("/V_OutOL")-v("/V_InP")) 0.0)))
  )
)

;; ---- corner 41 (tt41) / test drive_map
when(isDir("/home/mseminario2/chips/castalia/simarchive/anatop_tb_controlamp/Interactive.137/41/DriveMapTB/psf")
  openResults("/home/mseminario2/chips/castalia/simarchive/anatop_tb_controlamp/Interactive.137/41/DriveMapTB/psf")
  when(member('dc results())
    selectResult('dc)
    mtxP = outfile("/home/mseminario2/vestarv/implementations/asic/castalia/analog/data/raw/drive_map__tt41.meta" "w")
    fprintf(mtxP "sweep %%L\n" car(errset(sweepNames())))
    close(mtxP)
    errset(mtxDump("/home/mseminario2/vestarv/implementations/asic/castalia/analog/data/raw/drive_map__tt41__i_sink.csv" cross((v("/V_OutOL")-v("/V_InP")) 0.05 1 "falling")))
    errset(mtxDump("/home/mseminario2/vestarv/implementations/asic/castalia/analog/data/raw/drive_map__tt41__i_span.csv" (cross((v("/V_OutOL")-v("/V_InP")) -0.05 1 "falling")-cross((v("/V_OutOL")-v("/V_InP")) 0.05 1 "falling"))))
    errset(mtxDump("/home/mseminario2/vestarv/implementations/asic/castalia/analog/data/raw/drive_map__tt41__i_src.csv" cross((v("/V_OutOL")-v("/V_InP")) -0.05 1 "falling")))
    errset(mtxDump("/home/mseminario2/vestarv/implementations/asic/castalia/analog/data/raw/drive_map__tt41__idd_q.csv" value(abs(i("/POWER/SRC_VDD25/PLUS")) 0.0)))
    errset(mtxDump("/home/mseminario2/vestarv/implementations/asic/castalia/analog/data/raw/drive_map__tt41__rout.csv" abs((value(v("/V_OutOL") 0.5e-6)-value(v("/V_OutOL") -0.5e-6))/1e-6)))
    errset(mtxDump("/home/mseminario2/vestarv/implementations/asic/castalia/analog/data/raw/drive_map__tt41__verr.csv" (v("/V_OutOL")-v("/V_InP"))))
    errset(mtxDump("/home/mseminario2/vestarv/implementations/asic/castalia/analog/data/raw/drive_map__tt41__verr_q.csv" value((v("/V_OutOL")-v("/V_InP")) 0.0)))
  )
)

;; ---- corner 42 (ff42) / test drive_map
when(isDir("/home/mseminario2/chips/castalia/simarchive/anatop_tb_controlamp/Interactive.137/42/DriveMapTB/psf")
  openResults("/home/mseminario2/chips/castalia/simarchive/anatop_tb_controlamp/Interactive.137/42/DriveMapTB/psf")
  when(member('dc results())
    selectResult('dc)
    mtxP = outfile("/home/mseminario2/vestarv/implementations/asic/castalia/analog/data/raw/drive_map__ff42.meta" "w")
    fprintf(mtxP "sweep %%L\n" car(errset(sweepNames())))
    close(mtxP)
    errset(mtxDump("/home/mseminario2/vestarv/implementations/asic/castalia/analog/data/raw/drive_map__ff42__i_sink.csv" cross((v("/V_OutOL")-v("/V_InP")) 0.05 1 "falling")))
    errset(mtxDump("/home/mseminario2/vestarv/implementations/asic/castalia/analog/data/raw/drive_map__ff42__i_span.csv" (cross((v("/V_OutOL")-v("/V_InP")) -0.05 1 "falling")-cross((v("/V_OutOL")-v("/V_InP")) 0.05 1 "falling"))))
    errset(mtxDump("/home/mseminario2/vestarv/implementations/asic/castalia/analog/data/raw/drive_map__ff42__i_src.csv" cross((v("/V_OutOL")-v("/V_InP")) -0.05 1 "falling")))
    errset(mtxDump("/home/mseminario2/vestarv/implementations/asic/castalia/analog/data/raw/drive_map__ff42__idd_q.csv" value(abs(i("/POWER/SRC_VDD25/PLUS")) 0.0)))
    errset(mtxDump("/home/mseminario2/vestarv/implementations/asic/castalia/analog/data/raw/drive_map__ff42__rout.csv" abs((value(v("/V_OutOL") 0.5e-6)-value(v("/V_OutOL") -0.5e-6))/1e-6)))
    errset(mtxDump("/home/mseminario2/vestarv/implementations/asic/castalia/analog/data/raw/drive_map__ff42__verr.csv" (v("/V_OutOL")-v("/V_InP"))))
    errset(mtxDump("/home/mseminario2/vestarv/implementations/asic/castalia/analog/data/raw/drive_map__ff42__verr_q.csv" value((v("/V_OutOL")-v("/V_InP")) 0.0)))
  )
)

;; ---- corner 43 (fs43) / test drive_map
when(isDir("/home/mseminario2/chips/castalia/simarchive/anatop_tb_controlamp/Interactive.137/43/DriveMapTB/psf")
  openResults("/home/mseminario2/chips/castalia/simarchive/anatop_tb_controlamp/Interactive.137/43/DriveMapTB/psf")
  when(member('dc results())
    selectResult('dc)
    mtxP = outfile("/home/mseminario2/vestarv/implementations/asic/castalia/analog/data/raw/drive_map__fs43.meta" "w")
    fprintf(mtxP "sweep %%L\n" car(errset(sweepNames())))
    close(mtxP)
    errset(mtxDump("/home/mseminario2/vestarv/implementations/asic/castalia/analog/data/raw/drive_map__fs43__i_sink.csv" cross((v("/V_OutOL")-v("/V_InP")) 0.05 1 "falling")))
    errset(mtxDump("/home/mseminario2/vestarv/implementations/asic/castalia/analog/data/raw/drive_map__fs43__i_span.csv" (cross((v("/V_OutOL")-v("/V_InP")) -0.05 1 "falling")-cross((v("/V_OutOL")-v("/V_InP")) 0.05 1 "falling"))))
    errset(mtxDump("/home/mseminario2/vestarv/implementations/asic/castalia/analog/data/raw/drive_map__fs43__i_src.csv" cross((v("/V_OutOL")-v("/V_InP")) -0.05 1 "falling")))
    errset(mtxDump("/home/mseminario2/vestarv/implementations/asic/castalia/analog/data/raw/drive_map__fs43__idd_q.csv" value(abs(i("/POWER/SRC_VDD25/PLUS")) 0.0)))
    errset(mtxDump("/home/mseminario2/vestarv/implementations/asic/castalia/analog/data/raw/drive_map__fs43__rout.csv" abs((value(v("/V_OutOL") 0.5e-6)-value(v("/V_OutOL") -0.5e-6))/1e-6)))
    errset(mtxDump("/home/mseminario2/vestarv/implementations/asic/castalia/analog/data/raw/drive_map__fs43__verr.csv" (v("/V_OutOL")-v("/V_InP"))))
    errset(mtxDump("/home/mseminario2/vestarv/implementations/asic/castalia/analog/data/raw/drive_map__fs43__verr_q.csv" value((v("/V_OutOL")-v("/V_InP")) 0.0)))
  )
)

;; ---- corner 44 (sf44) / test drive_map
when(isDir("/home/mseminario2/chips/castalia/simarchive/anatop_tb_controlamp/Interactive.137/44/DriveMapTB/psf")
  openResults("/home/mseminario2/chips/castalia/simarchive/anatop_tb_controlamp/Interactive.137/44/DriveMapTB/psf")
  when(member('dc results())
    selectResult('dc)
    mtxP = outfile("/home/mseminario2/vestarv/implementations/asic/castalia/analog/data/raw/drive_map__sf44.meta" "w")
    fprintf(mtxP "sweep %%L\n" car(errset(sweepNames())))
    close(mtxP)
    errset(mtxDump("/home/mseminario2/vestarv/implementations/asic/castalia/analog/data/raw/drive_map__sf44__i_sink.csv" cross((v("/V_OutOL")-v("/V_InP")) 0.05 1 "falling")))
    errset(mtxDump("/home/mseminario2/vestarv/implementations/asic/castalia/analog/data/raw/drive_map__sf44__i_span.csv" (cross((v("/V_OutOL")-v("/V_InP")) -0.05 1 "falling")-cross((v("/V_OutOL")-v("/V_InP")) 0.05 1 "falling"))))
    errset(mtxDump("/home/mseminario2/vestarv/implementations/asic/castalia/analog/data/raw/drive_map__sf44__i_src.csv" cross((v("/V_OutOL")-v("/V_InP")) -0.05 1 "falling")))
    errset(mtxDump("/home/mseminario2/vestarv/implementations/asic/castalia/analog/data/raw/drive_map__sf44__idd_q.csv" value(abs(i("/POWER/SRC_VDD25/PLUS")) 0.0)))
    errset(mtxDump("/home/mseminario2/vestarv/implementations/asic/castalia/analog/data/raw/drive_map__sf44__rout.csv" abs((value(v("/V_OutOL") 0.5e-6)-value(v("/V_OutOL") -0.5e-6))/1e-6)))
    errset(mtxDump("/home/mseminario2/vestarv/implementations/asic/castalia/analog/data/raw/drive_map__sf44__verr.csv" (v("/V_OutOL")-v("/V_InP"))))
    errset(mtxDump("/home/mseminario2/vestarv/implementations/asic/castalia/analog/data/raw/drive_map__sf44__verr_q.csv" value((v("/V_OutOL")-v("/V_InP")) 0.0)))
  )
)

;; ---- corner 45 (ss45) / test drive_map
when(isDir("/home/mseminario2/chips/castalia/simarchive/anatop_tb_controlamp/Interactive.137/45/DriveMapTB/psf")
  openResults("/home/mseminario2/chips/castalia/simarchive/anatop_tb_controlamp/Interactive.137/45/DriveMapTB/psf")
  when(member('dc results())
    selectResult('dc)
    mtxP = outfile("/home/mseminario2/vestarv/implementations/asic/castalia/analog/data/raw/drive_map__ss45.meta" "w")
    fprintf(mtxP "sweep %%L\n" car(errset(sweepNames())))
    close(mtxP)
    errset(mtxDump("/home/mseminario2/vestarv/implementations/asic/castalia/analog/data/raw/drive_map__ss45__i_sink.csv" cross((v("/V_OutOL")-v("/V_InP")) 0.05 1 "falling")))
    errset(mtxDump("/home/mseminario2/vestarv/implementations/asic/castalia/analog/data/raw/drive_map__ss45__i_span.csv" (cross((v("/V_OutOL")-v("/V_InP")) -0.05 1 "falling")-cross((v("/V_OutOL")-v("/V_InP")) 0.05 1 "falling"))))
    errset(mtxDump("/home/mseminario2/vestarv/implementations/asic/castalia/analog/data/raw/drive_map__ss45__i_src.csv" cross((v("/V_OutOL")-v("/V_InP")) -0.05 1 "falling")))
    errset(mtxDump("/home/mseminario2/vestarv/implementations/asic/castalia/analog/data/raw/drive_map__ss45__idd_q.csv" value(abs(i("/POWER/SRC_VDD25/PLUS")) 0.0)))
    errset(mtxDump("/home/mseminario2/vestarv/implementations/asic/castalia/analog/data/raw/drive_map__ss45__rout.csv" abs((value(v("/V_OutOL") 0.5e-6)-value(v("/V_OutOL") -0.5e-6))/1e-6)))
    errset(mtxDump("/home/mseminario2/vestarv/implementations/asic/castalia/analog/data/raw/drive_map__ss45__verr.csv" (v("/V_OutOL")-v("/V_InP"))))
    errset(mtxDump("/home/mseminario2/vestarv/implementations/asic/castalia/analog/data/raw/drive_map__ss45__verr_q.csv" value((v("/V_OutOL")-v("/V_InP")) 0.0)))
  )
)

;; ---- corner 46 (tt46) / test drive_map
when(isDir("/home/mseminario2/chips/castalia/simarchive/anatop_tb_controlamp/Interactive.137/46/DriveMapTB/psf")
  openResults("/home/mseminario2/chips/castalia/simarchive/anatop_tb_controlamp/Interactive.137/46/DriveMapTB/psf")
  when(member('dc results())
    selectResult('dc)
    mtxP = outfile("/home/mseminario2/vestarv/implementations/asic/castalia/analog/data/raw/drive_map__tt46.meta" "w")
    fprintf(mtxP "sweep %%L\n" car(errset(sweepNames())))
    close(mtxP)
    errset(mtxDump("/home/mseminario2/vestarv/implementations/asic/castalia/analog/data/raw/drive_map__tt46__i_sink.csv" cross((v("/V_OutOL")-v("/V_InP")) 0.05 1 "falling")))
    errset(mtxDump("/home/mseminario2/vestarv/implementations/asic/castalia/analog/data/raw/drive_map__tt46__i_span.csv" (cross((v("/V_OutOL")-v("/V_InP")) -0.05 1 "falling")-cross((v("/V_OutOL")-v("/V_InP")) 0.05 1 "falling"))))
    errset(mtxDump("/home/mseminario2/vestarv/implementations/asic/castalia/analog/data/raw/drive_map__tt46__i_src.csv" cross((v("/V_OutOL")-v("/V_InP")) -0.05 1 "falling")))
    errset(mtxDump("/home/mseminario2/vestarv/implementations/asic/castalia/analog/data/raw/drive_map__tt46__idd_q.csv" value(abs(i("/POWER/SRC_VDD25/PLUS")) 0.0)))
    errset(mtxDump("/home/mseminario2/vestarv/implementations/asic/castalia/analog/data/raw/drive_map__tt46__rout.csv" abs((value(v("/V_OutOL") 0.5e-6)-value(v("/V_OutOL") -0.5e-6))/1e-6)))
    errset(mtxDump("/home/mseminario2/vestarv/implementations/asic/castalia/analog/data/raw/drive_map__tt46__verr.csv" (v("/V_OutOL")-v("/V_InP"))))
    errset(mtxDump("/home/mseminario2/vestarv/implementations/asic/castalia/analog/data/raw/drive_map__tt46__verr_q.csv" value((v("/V_OutOL")-v("/V_InP")) 0.0)))
  )
)

;; ---- corner 47 (ff47) / test drive_map
when(isDir("/home/mseminario2/chips/castalia/simarchive/anatop_tb_controlamp/Interactive.137/47/DriveMapTB/psf")
  openResults("/home/mseminario2/chips/castalia/simarchive/anatop_tb_controlamp/Interactive.137/47/DriveMapTB/psf")
  when(member('dc results())
    selectResult('dc)
    mtxP = outfile("/home/mseminario2/vestarv/implementations/asic/castalia/analog/data/raw/drive_map__ff47.meta" "w")
    fprintf(mtxP "sweep %%L\n" car(errset(sweepNames())))
    close(mtxP)
    errset(mtxDump("/home/mseminario2/vestarv/implementations/asic/castalia/analog/data/raw/drive_map__ff47__i_sink.csv" cross((v("/V_OutOL")-v("/V_InP")) 0.05 1 "falling")))
    errset(mtxDump("/home/mseminario2/vestarv/implementations/asic/castalia/analog/data/raw/drive_map__ff47__i_span.csv" (cross((v("/V_OutOL")-v("/V_InP")) -0.05 1 "falling")-cross((v("/V_OutOL")-v("/V_InP")) 0.05 1 "falling"))))
    errset(mtxDump("/home/mseminario2/vestarv/implementations/asic/castalia/analog/data/raw/drive_map__ff47__i_src.csv" cross((v("/V_OutOL")-v("/V_InP")) -0.05 1 "falling")))
    errset(mtxDump("/home/mseminario2/vestarv/implementations/asic/castalia/analog/data/raw/drive_map__ff47__idd_q.csv" value(abs(i("/POWER/SRC_VDD25/PLUS")) 0.0)))
    errset(mtxDump("/home/mseminario2/vestarv/implementations/asic/castalia/analog/data/raw/drive_map__ff47__rout.csv" abs((value(v("/V_OutOL") 0.5e-6)-value(v("/V_OutOL") -0.5e-6))/1e-6)))
    errset(mtxDump("/home/mseminario2/vestarv/implementations/asic/castalia/analog/data/raw/drive_map__ff47__verr.csv" (v("/V_OutOL")-v("/V_InP"))))
    errset(mtxDump("/home/mseminario2/vestarv/implementations/asic/castalia/analog/data/raw/drive_map__ff47__verr_q.csv" value((v("/V_OutOL")-v("/V_InP")) 0.0)))
  )
)

;; ---- corner 48 (fs48) / test drive_map
when(isDir("/home/mseminario2/chips/castalia/simarchive/anatop_tb_controlamp/Interactive.137/48/DriveMapTB/psf")
  openResults("/home/mseminario2/chips/castalia/simarchive/anatop_tb_controlamp/Interactive.137/48/DriveMapTB/psf")
  when(member('dc results())
    selectResult('dc)
    mtxP = outfile("/home/mseminario2/vestarv/implementations/asic/castalia/analog/data/raw/drive_map__fs48.meta" "w")
    fprintf(mtxP "sweep %%L\n" car(errset(sweepNames())))
    close(mtxP)
    errset(mtxDump("/home/mseminario2/vestarv/implementations/asic/castalia/analog/data/raw/drive_map__fs48__i_sink.csv" cross((v("/V_OutOL")-v("/V_InP")) 0.05 1 "falling")))
    errset(mtxDump("/home/mseminario2/vestarv/implementations/asic/castalia/analog/data/raw/drive_map__fs48__i_span.csv" (cross((v("/V_OutOL")-v("/V_InP")) -0.05 1 "falling")-cross((v("/V_OutOL")-v("/V_InP")) 0.05 1 "falling"))))
    errset(mtxDump("/home/mseminario2/vestarv/implementations/asic/castalia/analog/data/raw/drive_map__fs48__i_src.csv" cross((v("/V_OutOL")-v("/V_InP")) -0.05 1 "falling")))
    errset(mtxDump("/home/mseminario2/vestarv/implementations/asic/castalia/analog/data/raw/drive_map__fs48__idd_q.csv" value(abs(i("/POWER/SRC_VDD25/PLUS")) 0.0)))
    errset(mtxDump("/home/mseminario2/vestarv/implementations/asic/castalia/analog/data/raw/drive_map__fs48__rout.csv" abs((value(v("/V_OutOL") 0.5e-6)-value(v("/V_OutOL") -0.5e-6))/1e-6)))
    errset(mtxDump("/home/mseminario2/vestarv/implementations/asic/castalia/analog/data/raw/drive_map__fs48__verr.csv" (v("/V_OutOL")-v("/V_InP"))))
    errset(mtxDump("/home/mseminario2/vestarv/implementations/asic/castalia/analog/data/raw/drive_map__fs48__verr_q.csv" value((v("/V_OutOL")-v("/V_InP")) 0.0)))
  )
)

;; ---- corner 49 (sf49) / test drive_map
when(isDir("/home/mseminario2/chips/castalia/simarchive/anatop_tb_controlamp/Interactive.137/49/DriveMapTB/psf")
  openResults("/home/mseminario2/chips/castalia/simarchive/anatop_tb_controlamp/Interactive.137/49/DriveMapTB/psf")
  when(member('dc results())
    selectResult('dc)
    mtxP = outfile("/home/mseminario2/vestarv/implementations/asic/castalia/analog/data/raw/drive_map__sf49.meta" "w")
    fprintf(mtxP "sweep %%L\n" car(errset(sweepNames())))
    close(mtxP)
    errset(mtxDump("/home/mseminario2/vestarv/implementations/asic/castalia/analog/data/raw/drive_map__sf49__i_sink.csv" cross((v("/V_OutOL")-v("/V_InP")) 0.05 1 "falling")))
    errset(mtxDump("/home/mseminario2/vestarv/implementations/asic/castalia/analog/data/raw/drive_map__sf49__i_span.csv" (cross((v("/V_OutOL")-v("/V_InP")) -0.05 1 "falling")-cross((v("/V_OutOL")-v("/V_InP")) 0.05 1 "falling"))))
    errset(mtxDump("/home/mseminario2/vestarv/implementations/asic/castalia/analog/data/raw/drive_map__sf49__i_src.csv" cross((v("/V_OutOL")-v("/V_InP")) -0.05 1 "falling")))
    errset(mtxDump("/home/mseminario2/vestarv/implementations/asic/castalia/analog/data/raw/drive_map__sf49__idd_q.csv" value(abs(i("/POWER/SRC_VDD25/PLUS")) 0.0)))
    errset(mtxDump("/home/mseminario2/vestarv/implementations/asic/castalia/analog/data/raw/drive_map__sf49__rout.csv" abs((value(v("/V_OutOL") 0.5e-6)-value(v("/V_OutOL") -0.5e-6))/1e-6)))
    errset(mtxDump("/home/mseminario2/vestarv/implementations/asic/castalia/analog/data/raw/drive_map__sf49__verr.csv" (v("/V_OutOL")-v("/V_InP"))))
    errset(mtxDump("/home/mseminario2/vestarv/implementations/asic/castalia/analog/data/raw/drive_map__sf49__verr_q.csv" value((v("/V_OutOL")-v("/V_InP")) 0.0)))
  )
)

;; ---- corner 50 (ss50) / test drive_map
when(isDir("/home/mseminario2/chips/castalia/simarchive/anatop_tb_controlamp/Interactive.137/50/DriveMapTB/psf")
  openResults("/home/mseminario2/chips/castalia/simarchive/anatop_tb_controlamp/Interactive.137/50/DriveMapTB/psf")
  when(member('dc results())
    selectResult('dc)
    mtxP = outfile("/home/mseminario2/vestarv/implementations/asic/castalia/analog/data/raw/drive_map__ss50.meta" "w")
    fprintf(mtxP "sweep %%L\n" car(errset(sweepNames())))
    close(mtxP)
    errset(mtxDump("/home/mseminario2/vestarv/implementations/asic/castalia/analog/data/raw/drive_map__ss50__i_sink.csv" cross((v("/V_OutOL")-v("/V_InP")) 0.05 1 "falling")))
    errset(mtxDump("/home/mseminario2/vestarv/implementations/asic/castalia/analog/data/raw/drive_map__ss50__i_span.csv" (cross((v("/V_OutOL")-v("/V_InP")) -0.05 1 "falling")-cross((v("/V_OutOL")-v("/V_InP")) 0.05 1 "falling"))))
    errset(mtxDump("/home/mseminario2/vestarv/implementations/asic/castalia/analog/data/raw/drive_map__ss50__i_src.csv" cross((v("/V_OutOL")-v("/V_InP")) -0.05 1 "falling")))
    errset(mtxDump("/home/mseminario2/vestarv/implementations/asic/castalia/analog/data/raw/drive_map__ss50__idd_q.csv" value(abs(i("/POWER/SRC_VDD25/PLUS")) 0.0)))
    errset(mtxDump("/home/mseminario2/vestarv/implementations/asic/castalia/analog/data/raw/drive_map__ss50__rout.csv" abs((value(v("/V_OutOL") 0.5e-6)-value(v("/V_OutOL") -0.5e-6))/1e-6)))
    errset(mtxDump("/home/mseminario2/vestarv/implementations/asic/castalia/analog/data/raw/drive_map__ss50__verr.csv" (v("/V_OutOL")-v("/V_InP"))))
    errset(mtxDump("/home/mseminario2/vestarv/implementations/asic/castalia/analog/data/raw/drive_map__ss50__verr_q.csv" value((v("/V_OutOL")-v("/V_InP")) 0.0)))
  )
)

;; ---- corner 51 (tt51) / test drive_map
when(isDir("/home/mseminario2/chips/castalia/simarchive/anatop_tb_controlamp/Interactive.137/51/DriveMapTB/psf")
  openResults("/home/mseminario2/chips/castalia/simarchive/anatop_tb_controlamp/Interactive.137/51/DriveMapTB/psf")
  when(member('dc results())
    selectResult('dc)
    mtxP = outfile("/home/mseminario2/vestarv/implementations/asic/castalia/analog/data/raw/drive_map__tt51.meta" "w")
    fprintf(mtxP "sweep %%L\n" car(errset(sweepNames())))
    close(mtxP)
    errset(mtxDump("/home/mseminario2/vestarv/implementations/asic/castalia/analog/data/raw/drive_map__tt51__i_sink.csv" cross((v("/V_OutOL")-v("/V_InP")) 0.05 1 "falling")))
    errset(mtxDump("/home/mseminario2/vestarv/implementations/asic/castalia/analog/data/raw/drive_map__tt51__i_span.csv" (cross((v("/V_OutOL")-v("/V_InP")) -0.05 1 "falling")-cross((v("/V_OutOL")-v("/V_InP")) 0.05 1 "falling"))))
    errset(mtxDump("/home/mseminario2/vestarv/implementations/asic/castalia/analog/data/raw/drive_map__tt51__i_src.csv" cross((v("/V_OutOL")-v("/V_InP")) -0.05 1 "falling")))
    errset(mtxDump("/home/mseminario2/vestarv/implementations/asic/castalia/analog/data/raw/drive_map__tt51__idd_q.csv" value(abs(i("/POWER/SRC_VDD25/PLUS")) 0.0)))
    errset(mtxDump("/home/mseminario2/vestarv/implementations/asic/castalia/analog/data/raw/drive_map__tt51__rout.csv" abs((value(v("/V_OutOL") 0.5e-6)-value(v("/V_OutOL") -0.5e-6))/1e-6)))
    errset(mtxDump("/home/mseminario2/vestarv/implementations/asic/castalia/analog/data/raw/drive_map__tt51__verr.csv" (v("/V_OutOL")-v("/V_InP"))))
    errset(mtxDump("/home/mseminario2/vestarv/implementations/asic/castalia/analog/data/raw/drive_map__tt51__verr_q.csv" value((v("/V_OutOL")-v("/V_InP")) 0.0)))
  )
)

;; ---- corner 52 (ff52) / test drive_map
when(isDir("/home/mseminario2/chips/castalia/simarchive/anatop_tb_controlamp/Interactive.137/52/DriveMapTB/psf")
  openResults("/home/mseminario2/chips/castalia/simarchive/anatop_tb_controlamp/Interactive.137/52/DriveMapTB/psf")
  when(member('dc results())
    selectResult('dc)
    mtxP = outfile("/home/mseminario2/vestarv/implementations/asic/castalia/analog/data/raw/drive_map__ff52.meta" "w")
    fprintf(mtxP "sweep %%L\n" car(errset(sweepNames())))
    close(mtxP)
    errset(mtxDump("/home/mseminario2/vestarv/implementations/asic/castalia/analog/data/raw/drive_map__ff52__i_sink.csv" cross((v("/V_OutOL")-v("/V_InP")) 0.05 1 "falling")))
    errset(mtxDump("/home/mseminario2/vestarv/implementations/asic/castalia/analog/data/raw/drive_map__ff52__i_span.csv" (cross((v("/V_OutOL")-v("/V_InP")) -0.05 1 "falling")-cross((v("/V_OutOL")-v("/V_InP")) 0.05 1 "falling"))))
    errset(mtxDump("/home/mseminario2/vestarv/implementations/asic/castalia/analog/data/raw/drive_map__ff52__i_src.csv" cross((v("/V_OutOL")-v("/V_InP")) -0.05 1 "falling")))
    errset(mtxDump("/home/mseminario2/vestarv/implementations/asic/castalia/analog/data/raw/drive_map__ff52__idd_q.csv" value(abs(i("/POWER/SRC_VDD25/PLUS")) 0.0)))
    errset(mtxDump("/home/mseminario2/vestarv/implementations/asic/castalia/analog/data/raw/drive_map__ff52__rout.csv" abs((value(v("/V_OutOL") 0.5e-6)-value(v("/V_OutOL") -0.5e-6))/1e-6)))
    errset(mtxDump("/home/mseminario2/vestarv/implementations/asic/castalia/analog/data/raw/drive_map__ff52__verr.csv" (v("/V_OutOL")-v("/V_InP"))))
    errset(mtxDump("/home/mseminario2/vestarv/implementations/asic/castalia/analog/data/raw/drive_map__ff52__verr_q.csv" value((v("/V_OutOL")-v("/V_InP")) 0.0)))
  )
)

;; ---- corner 53 (fs53) / test drive_map
when(isDir("/home/mseminario2/chips/castalia/simarchive/anatop_tb_controlamp/Interactive.137/53/DriveMapTB/psf")
  openResults("/home/mseminario2/chips/castalia/simarchive/anatop_tb_controlamp/Interactive.137/53/DriveMapTB/psf")
  when(member('dc results())
    selectResult('dc)
    mtxP = outfile("/home/mseminario2/vestarv/implementations/asic/castalia/analog/data/raw/drive_map__fs53.meta" "w")
    fprintf(mtxP "sweep %%L\n" car(errset(sweepNames())))
    close(mtxP)
    errset(mtxDump("/home/mseminario2/vestarv/implementations/asic/castalia/analog/data/raw/drive_map__fs53__i_sink.csv" cross((v("/V_OutOL")-v("/V_InP")) 0.05 1 "falling")))
    errset(mtxDump("/home/mseminario2/vestarv/implementations/asic/castalia/analog/data/raw/drive_map__fs53__i_span.csv" (cross((v("/V_OutOL")-v("/V_InP")) -0.05 1 "falling")-cross((v("/V_OutOL")-v("/V_InP")) 0.05 1 "falling"))))
    errset(mtxDump("/home/mseminario2/vestarv/implementations/asic/castalia/analog/data/raw/drive_map__fs53__i_src.csv" cross((v("/V_OutOL")-v("/V_InP")) -0.05 1 "falling")))
    errset(mtxDump("/home/mseminario2/vestarv/implementations/asic/castalia/analog/data/raw/drive_map__fs53__idd_q.csv" value(abs(i("/POWER/SRC_VDD25/PLUS")) 0.0)))
    errset(mtxDump("/home/mseminario2/vestarv/implementations/asic/castalia/analog/data/raw/drive_map__fs53__rout.csv" abs((value(v("/V_OutOL") 0.5e-6)-value(v("/V_OutOL") -0.5e-6))/1e-6)))
    errset(mtxDump("/home/mseminario2/vestarv/implementations/asic/castalia/analog/data/raw/drive_map__fs53__verr.csv" (v("/V_OutOL")-v("/V_InP"))))
    errset(mtxDump("/home/mseminario2/vestarv/implementations/asic/castalia/analog/data/raw/drive_map__fs53__verr_q.csv" value((v("/V_OutOL")-v("/V_InP")) 0.0)))
  )
)

;; ---- corner 54 (sf54) / test drive_map
when(isDir("/home/mseminario2/chips/castalia/simarchive/anatop_tb_controlamp/Interactive.137/54/DriveMapTB/psf")
  openResults("/home/mseminario2/chips/castalia/simarchive/anatop_tb_controlamp/Interactive.137/54/DriveMapTB/psf")
  when(member('dc results())
    selectResult('dc)
    mtxP = outfile("/home/mseminario2/vestarv/implementations/asic/castalia/analog/data/raw/drive_map__sf54.meta" "w")
    fprintf(mtxP "sweep %%L\n" car(errset(sweepNames())))
    close(mtxP)
    errset(mtxDump("/home/mseminario2/vestarv/implementations/asic/castalia/analog/data/raw/drive_map__sf54__i_sink.csv" cross((v("/V_OutOL")-v("/V_InP")) 0.05 1 "falling")))
    errset(mtxDump("/home/mseminario2/vestarv/implementations/asic/castalia/analog/data/raw/drive_map__sf54__i_span.csv" (cross((v("/V_OutOL")-v("/V_InP")) -0.05 1 "falling")-cross((v("/V_OutOL")-v("/V_InP")) 0.05 1 "falling"))))
    errset(mtxDump("/home/mseminario2/vestarv/implementations/asic/castalia/analog/data/raw/drive_map__sf54__i_src.csv" cross((v("/V_OutOL")-v("/V_InP")) -0.05 1 "falling")))
    errset(mtxDump("/home/mseminario2/vestarv/implementations/asic/castalia/analog/data/raw/drive_map__sf54__idd_q.csv" value(abs(i("/POWER/SRC_VDD25/PLUS")) 0.0)))
    errset(mtxDump("/home/mseminario2/vestarv/implementations/asic/castalia/analog/data/raw/drive_map__sf54__rout.csv" abs((value(v("/V_OutOL") 0.5e-6)-value(v("/V_OutOL") -0.5e-6))/1e-6)))
    errset(mtxDump("/home/mseminario2/vestarv/implementations/asic/castalia/analog/data/raw/drive_map__sf54__verr.csv" (v("/V_OutOL")-v("/V_InP"))))
    errset(mtxDump("/home/mseminario2/vestarv/implementations/asic/castalia/analog/data/raw/drive_map__sf54__verr_q.csv" value((v("/V_OutOL")-v("/V_InP")) 0.0)))
  )
)

;; ---- corner 55 (ss55) / test drive_map
when(isDir("/home/mseminario2/chips/castalia/simarchive/anatop_tb_controlamp/Interactive.137/55/DriveMapTB/psf")
  openResults("/home/mseminario2/chips/castalia/simarchive/anatop_tb_controlamp/Interactive.137/55/DriveMapTB/psf")
  when(member('dc results())
    selectResult('dc)
    mtxP = outfile("/home/mseminario2/vestarv/implementations/asic/castalia/analog/data/raw/drive_map__ss55.meta" "w")
    fprintf(mtxP "sweep %%L\n" car(errset(sweepNames())))
    close(mtxP)
    errset(mtxDump("/home/mseminario2/vestarv/implementations/asic/castalia/analog/data/raw/drive_map__ss55__i_sink.csv" cross((v("/V_OutOL")-v("/V_InP")) 0.05 1 "falling")))
    errset(mtxDump("/home/mseminario2/vestarv/implementations/asic/castalia/analog/data/raw/drive_map__ss55__i_span.csv" (cross((v("/V_OutOL")-v("/V_InP")) -0.05 1 "falling")-cross((v("/V_OutOL")-v("/V_InP")) 0.05 1 "falling"))))
    errset(mtxDump("/home/mseminario2/vestarv/implementations/asic/castalia/analog/data/raw/drive_map__ss55__i_src.csv" cross((v("/V_OutOL")-v("/V_InP")) -0.05 1 "falling")))
    errset(mtxDump("/home/mseminario2/vestarv/implementations/asic/castalia/analog/data/raw/drive_map__ss55__idd_q.csv" value(abs(i("/POWER/SRC_VDD25/PLUS")) 0.0)))
    errset(mtxDump("/home/mseminario2/vestarv/implementations/asic/castalia/analog/data/raw/drive_map__ss55__rout.csv" abs((value(v("/V_OutOL") 0.5e-6)-value(v("/V_OutOL") -0.5e-6))/1e-6)))
    errset(mtxDump("/home/mseminario2/vestarv/implementations/asic/castalia/analog/data/raw/drive_map__ss55__verr.csv" (v("/V_OutOL")-v("/V_InP"))))
    errset(mtxDump("/home/mseminario2/vestarv/implementations/asic/castalia/analog/data/raw/drive_map__ss55__verr_q.csv" value((v("/V_OutOL")-v("/V_InP")) 0.0)))
  )
)

;; ---- corner 56 (tt56) / test drive_map
when(isDir("/home/mseminario2/chips/castalia/simarchive/anatop_tb_controlamp/Interactive.137/56/DriveMapTB/psf")
  openResults("/home/mseminario2/chips/castalia/simarchive/anatop_tb_controlamp/Interactive.137/56/DriveMapTB/psf")
  when(member('dc results())
    selectResult('dc)
    mtxP = outfile("/home/mseminario2/vestarv/implementations/asic/castalia/analog/data/raw/drive_map__tt56.meta" "w")
    fprintf(mtxP "sweep %%L\n" car(errset(sweepNames())))
    close(mtxP)
    errset(mtxDump("/home/mseminario2/vestarv/implementations/asic/castalia/analog/data/raw/drive_map__tt56__i_sink.csv" cross((v("/V_OutOL")-v("/V_InP")) 0.05 1 "falling")))
    errset(mtxDump("/home/mseminario2/vestarv/implementations/asic/castalia/analog/data/raw/drive_map__tt56__i_span.csv" (cross((v("/V_OutOL")-v("/V_InP")) -0.05 1 "falling")-cross((v("/V_OutOL")-v("/V_InP")) 0.05 1 "falling"))))
    errset(mtxDump("/home/mseminario2/vestarv/implementations/asic/castalia/analog/data/raw/drive_map__tt56__i_src.csv" cross((v("/V_OutOL")-v("/V_InP")) -0.05 1 "falling")))
    errset(mtxDump("/home/mseminario2/vestarv/implementations/asic/castalia/analog/data/raw/drive_map__tt56__idd_q.csv" value(abs(i("/POWER/SRC_VDD25/PLUS")) 0.0)))
    errset(mtxDump("/home/mseminario2/vestarv/implementations/asic/castalia/analog/data/raw/drive_map__tt56__rout.csv" abs((value(v("/V_OutOL") 0.5e-6)-value(v("/V_OutOL") -0.5e-6))/1e-6)))
    errset(mtxDump("/home/mseminario2/vestarv/implementations/asic/castalia/analog/data/raw/drive_map__tt56__verr.csv" (v("/V_OutOL")-v("/V_InP"))))
    errset(mtxDump("/home/mseminario2/vestarv/implementations/asic/castalia/analog/data/raw/drive_map__tt56__verr_q.csv" value((v("/V_OutOL")-v("/V_InP")) 0.0)))
  )
)

;; ---- corner 57 (ff57) / test drive_map
when(isDir("/home/mseminario2/chips/castalia/simarchive/anatop_tb_controlamp/Interactive.137/57/DriveMapTB/psf")
  openResults("/home/mseminario2/chips/castalia/simarchive/anatop_tb_controlamp/Interactive.137/57/DriveMapTB/psf")
  when(member('dc results())
    selectResult('dc)
    mtxP = outfile("/home/mseminario2/vestarv/implementations/asic/castalia/analog/data/raw/drive_map__ff57.meta" "w")
    fprintf(mtxP "sweep %%L\n" car(errset(sweepNames())))
    close(mtxP)
    errset(mtxDump("/home/mseminario2/vestarv/implementations/asic/castalia/analog/data/raw/drive_map__ff57__i_sink.csv" cross((v("/V_OutOL")-v("/V_InP")) 0.05 1 "falling")))
    errset(mtxDump("/home/mseminario2/vestarv/implementations/asic/castalia/analog/data/raw/drive_map__ff57__i_span.csv" (cross((v("/V_OutOL")-v("/V_InP")) -0.05 1 "falling")-cross((v("/V_OutOL")-v("/V_InP")) 0.05 1 "falling"))))
    errset(mtxDump("/home/mseminario2/vestarv/implementations/asic/castalia/analog/data/raw/drive_map__ff57__i_src.csv" cross((v("/V_OutOL")-v("/V_InP")) -0.05 1 "falling")))
    errset(mtxDump("/home/mseminario2/vestarv/implementations/asic/castalia/analog/data/raw/drive_map__ff57__idd_q.csv" value(abs(i("/POWER/SRC_VDD25/PLUS")) 0.0)))
    errset(mtxDump("/home/mseminario2/vestarv/implementations/asic/castalia/analog/data/raw/drive_map__ff57__rout.csv" abs((value(v("/V_OutOL") 0.5e-6)-value(v("/V_OutOL") -0.5e-6))/1e-6)))
    errset(mtxDump("/home/mseminario2/vestarv/implementations/asic/castalia/analog/data/raw/drive_map__ff57__verr.csv" (v("/V_OutOL")-v("/V_InP"))))
    errset(mtxDump("/home/mseminario2/vestarv/implementations/asic/castalia/analog/data/raw/drive_map__ff57__verr_q.csv" value((v("/V_OutOL")-v("/V_InP")) 0.0)))
  )
)

;; ---- corner 58 (fs58) / test drive_map
when(isDir("/home/mseminario2/chips/castalia/simarchive/anatop_tb_controlamp/Interactive.137/58/DriveMapTB/psf")
  openResults("/home/mseminario2/chips/castalia/simarchive/anatop_tb_controlamp/Interactive.137/58/DriveMapTB/psf")
  when(member('dc results())
    selectResult('dc)
    mtxP = outfile("/home/mseminario2/vestarv/implementations/asic/castalia/analog/data/raw/drive_map__fs58.meta" "w")
    fprintf(mtxP "sweep %%L\n" car(errset(sweepNames())))
    close(mtxP)
    errset(mtxDump("/home/mseminario2/vestarv/implementations/asic/castalia/analog/data/raw/drive_map__fs58__i_sink.csv" cross((v("/V_OutOL")-v("/V_InP")) 0.05 1 "falling")))
    errset(mtxDump("/home/mseminario2/vestarv/implementations/asic/castalia/analog/data/raw/drive_map__fs58__i_span.csv" (cross((v("/V_OutOL")-v("/V_InP")) -0.05 1 "falling")-cross((v("/V_OutOL")-v("/V_InP")) 0.05 1 "falling"))))
    errset(mtxDump("/home/mseminario2/vestarv/implementations/asic/castalia/analog/data/raw/drive_map__fs58__i_src.csv" cross((v("/V_OutOL")-v("/V_InP")) -0.05 1 "falling")))
    errset(mtxDump("/home/mseminario2/vestarv/implementations/asic/castalia/analog/data/raw/drive_map__fs58__idd_q.csv" value(abs(i("/POWER/SRC_VDD25/PLUS")) 0.0)))
    errset(mtxDump("/home/mseminario2/vestarv/implementations/asic/castalia/analog/data/raw/drive_map__fs58__rout.csv" abs((value(v("/V_OutOL") 0.5e-6)-value(v("/V_OutOL") -0.5e-6))/1e-6)))
    errset(mtxDump("/home/mseminario2/vestarv/implementations/asic/castalia/analog/data/raw/drive_map__fs58__verr.csv" (v("/V_OutOL")-v("/V_InP"))))
    errset(mtxDump("/home/mseminario2/vestarv/implementations/asic/castalia/analog/data/raw/drive_map__fs58__verr_q.csv" value((v("/V_OutOL")-v("/V_InP")) 0.0)))
  )
)

;; ---- corner 59 (sf59) / test drive_map
when(isDir("/home/mseminario2/chips/castalia/simarchive/anatop_tb_controlamp/Interactive.137/59/DriveMapTB/psf")
  openResults("/home/mseminario2/chips/castalia/simarchive/anatop_tb_controlamp/Interactive.137/59/DriveMapTB/psf")
  when(member('dc results())
    selectResult('dc)
    mtxP = outfile("/home/mseminario2/vestarv/implementations/asic/castalia/analog/data/raw/drive_map__sf59.meta" "w")
    fprintf(mtxP "sweep %%L\n" car(errset(sweepNames())))
    close(mtxP)
    errset(mtxDump("/home/mseminario2/vestarv/implementations/asic/castalia/analog/data/raw/drive_map__sf59__i_sink.csv" cross((v("/V_OutOL")-v("/V_InP")) 0.05 1 "falling")))
    errset(mtxDump("/home/mseminario2/vestarv/implementations/asic/castalia/analog/data/raw/drive_map__sf59__i_span.csv" (cross((v("/V_OutOL")-v("/V_InP")) -0.05 1 "falling")-cross((v("/V_OutOL")-v("/V_InP")) 0.05 1 "falling"))))
    errset(mtxDump("/home/mseminario2/vestarv/implementations/asic/castalia/analog/data/raw/drive_map__sf59__i_src.csv" cross((v("/V_OutOL")-v("/V_InP")) -0.05 1 "falling")))
    errset(mtxDump("/home/mseminario2/vestarv/implementations/asic/castalia/analog/data/raw/drive_map__sf59__idd_q.csv" value(abs(i("/POWER/SRC_VDD25/PLUS")) 0.0)))
    errset(mtxDump("/home/mseminario2/vestarv/implementations/asic/castalia/analog/data/raw/drive_map__sf59__rout.csv" abs((value(v("/V_OutOL") 0.5e-6)-value(v("/V_OutOL") -0.5e-6))/1e-6)))
    errset(mtxDump("/home/mseminario2/vestarv/implementations/asic/castalia/analog/data/raw/drive_map__sf59__verr.csv" (v("/V_OutOL")-v("/V_InP"))))
    errset(mtxDump("/home/mseminario2/vestarv/implementations/asic/castalia/analog/data/raw/drive_map__sf59__verr_q.csv" value((v("/V_OutOL")-v("/V_InP")) 0.0)))
  )
)

;; ---- corner 60 (ss60) / test drive_map
when(isDir("/home/mseminario2/chips/castalia/simarchive/anatop_tb_controlamp/Interactive.137/60/DriveMapTB/psf")
  openResults("/home/mseminario2/chips/castalia/simarchive/anatop_tb_controlamp/Interactive.137/60/DriveMapTB/psf")
  when(member('dc results())
    selectResult('dc)
    mtxP = outfile("/home/mseminario2/vestarv/implementations/asic/castalia/analog/data/raw/drive_map__ss60.meta" "w")
    fprintf(mtxP "sweep %%L\n" car(errset(sweepNames())))
    close(mtxP)
    errset(mtxDump("/home/mseminario2/vestarv/implementations/asic/castalia/analog/data/raw/drive_map__ss60__i_sink.csv" cross((v("/V_OutOL")-v("/V_InP")) 0.05 1 "falling")))
    errset(mtxDump("/home/mseminario2/vestarv/implementations/asic/castalia/analog/data/raw/drive_map__ss60__i_span.csv" (cross((v("/V_OutOL")-v("/V_InP")) -0.05 1 "falling")-cross((v("/V_OutOL")-v("/V_InP")) 0.05 1 "falling"))))
    errset(mtxDump("/home/mseminario2/vestarv/implementations/asic/castalia/analog/data/raw/drive_map__ss60__i_src.csv" cross((v("/V_OutOL")-v("/V_InP")) -0.05 1 "falling")))
    errset(mtxDump("/home/mseminario2/vestarv/implementations/asic/castalia/analog/data/raw/drive_map__ss60__idd_q.csv" value(abs(i("/POWER/SRC_VDD25/PLUS")) 0.0)))
    errset(mtxDump("/home/mseminario2/vestarv/implementations/asic/castalia/analog/data/raw/drive_map__ss60__rout.csv" abs((value(v("/V_OutOL") 0.5e-6)-value(v("/V_OutOL") -0.5e-6))/1e-6)))
    errset(mtxDump("/home/mseminario2/vestarv/implementations/asic/castalia/analog/data/raw/drive_map__ss60__verr.csv" (v("/V_OutOL")-v("/V_InP"))))
    errset(mtxDump("/home/mseminario2/vestarv/implementations/asic/castalia/analog/data/raw/drive_map__ss60__verr_q.csv" value((v("/V_OutOL")-v("/V_InP")) 0.0)))
  )
)

;; ---- corner 61 (tt61) / test drive_map
when(isDir("/home/mseminario2/chips/castalia/simarchive/anatop_tb_controlamp/Interactive.137/61/DriveMapTB/psf")
  openResults("/home/mseminario2/chips/castalia/simarchive/anatop_tb_controlamp/Interactive.137/61/DriveMapTB/psf")
  when(member('dc results())
    selectResult('dc)
    mtxP = outfile("/home/mseminario2/vestarv/implementations/asic/castalia/analog/data/raw/drive_map__tt61.meta" "w")
    fprintf(mtxP "sweep %%L\n" car(errset(sweepNames())))
    close(mtxP)
    errset(mtxDump("/home/mseminario2/vestarv/implementations/asic/castalia/analog/data/raw/drive_map__tt61__i_sink.csv" cross((v("/V_OutOL")-v("/V_InP")) 0.05 1 "falling")))
    errset(mtxDump("/home/mseminario2/vestarv/implementations/asic/castalia/analog/data/raw/drive_map__tt61__i_span.csv" (cross((v("/V_OutOL")-v("/V_InP")) -0.05 1 "falling")-cross((v("/V_OutOL")-v("/V_InP")) 0.05 1 "falling"))))
    errset(mtxDump("/home/mseminario2/vestarv/implementations/asic/castalia/analog/data/raw/drive_map__tt61__i_src.csv" cross((v("/V_OutOL")-v("/V_InP")) -0.05 1 "falling")))
    errset(mtxDump("/home/mseminario2/vestarv/implementations/asic/castalia/analog/data/raw/drive_map__tt61__idd_q.csv" value(abs(i("/POWER/SRC_VDD25/PLUS")) 0.0)))
    errset(mtxDump("/home/mseminario2/vestarv/implementations/asic/castalia/analog/data/raw/drive_map__tt61__rout.csv" abs((value(v("/V_OutOL") 0.5e-6)-value(v("/V_OutOL") -0.5e-6))/1e-6)))
    errset(mtxDump("/home/mseminario2/vestarv/implementations/asic/castalia/analog/data/raw/drive_map__tt61__verr.csv" (v("/V_OutOL")-v("/V_InP"))))
    errset(mtxDump("/home/mseminario2/vestarv/implementations/asic/castalia/analog/data/raw/drive_map__tt61__verr_q.csv" value((v("/V_OutOL")-v("/V_InP")) 0.0)))
  )
)

;; ---- corner 62 (ff62) / test drive_map
when(isDir("/home/mseminario2/chips/castalia/simarchive/anatop_tb_controlamp/Interactive.137/62/DriveMapTB/psf")
  openResults("/home/mseminario2/chips/castalia/simarchive/anatop_tb_controlamp/Interactive.137/62/DriveMapTB/psf")
  when(member('dc results())
    selectResult('dc)
    mtxP = outfile("/home/mseminario2/vestarv/implementations/asic/castalia/analog/data/raw/drive_map__ff62.meta" "w")
    fprintf(mtxP "sweep %%L\n" car(errset(sweepNames())))
    close(mtxP)
    errset(mtxDump("/home/mseminario2/vestarv/implementations/asic/castalia/analog/data/raw/drive_map__ff62__i_sink.csv" cross((v("/V_OutOL")-v("/V_InP")) 0.05 1 "falling")))
    errset(mtxDump("/home/mseminario2/vestarv/implementations/asic/castalia/analog/data/raw/drive_map__ff62__i_span.csv" (cross((v("/V_OutOL")-v("/V_InP")) -0.05 1 "falling")-cross((v("/V_OutOL")-v("/V_InP")) 0.05 1 "falling"))))
    errset(mtxDump("/home/mseminario2/vestarv/implementations/asic/castalia/analog/data/raw/drive_map__ff62__i_src.csv" cross((v("/V_OutOL")-v("/V_InP")) -0.05 1 "falling")))
    errset(mtxDump("/home/mseminario2/vestarv/implementations/asic/castalia/analog/data/raw/drive_map__ff62__idd_q.csv" value(abs(i("/POWER/SRC_VDD25/PLUS")) 0.0)))
    errset(mtxDump("/home/mseminario2/vestarv/implementations/asic/castalia/analog/data/raw/drive_map__ff62__rout.csv" abs((value(v("/V_OutOL") 0.5e-6)-value(v("/V_OutOL") -0.5e-6))/1e-6)))
    errset(mtxDump("/home/mseminario2/vestarv/implementations/asic/castalia/analog/data/raw/drive_map__ff62__verr.csv" (v("/V_OutOL")-v("/V_InP"))))
    errset(mtxDump("/home/mseminario2/vestarv/implementations/asic/castalia/analog/data/raw/drive_map__ff62__verr_q.csv" value((v("/V_OutOL")-v("/V_InP")) 0.0)))
  )
)

;; ---- corner 63 (fs63) / test drive_map
when(isDir("/home/mseminario2/chips/castalia/simarchive/anatop_tb_controlamp/Interactive.137/63/DriveMapTB/psf")
  openResults("/home/mseminario2/chips/castalia/simarchive/anatop_tb_controlamp/Interactive.137/63/DriveMapTB/psf")
  when(member('dc results())
    selectResult('dc)
    mtxP = outfile("/home/mseminario2/vestarv/implementations/asic/castalia/analog/data/raw/drive_map__fs63.meta" "w")
    fprintf(mtxP "sweep %%L\n" car(errset(sweepNames())))
    close(mtxP)
    errset(mtxDump("/home/mseminario2/vestarv/implementations/asic/castalia/analog/data/raw/drive_map__fs63__i_sink.csv" cross((v("/V_OutOL")-v("/V_InP")) 0.05 1 "falling")))
    errset(mtxDump("/home/mseminario2/vestarv/implementations/asic/castalia/analog/data/raw/drive_map__fs63__i_span.csv" (cross((v("/V_OutOL")-v("/V_InP")) -0.05 1 "falling")-cross((v("/V_OutOL")-v("/V_InP")) 0.05 1 "falling"))))
    errset(mtxDump("/home/mseminario2/vestarv/implementations/asic/castalia/analog/data/raw/drive_map__fs63__i_src.csv" cross((v("/V_OutOL")-v("/V_InP")) -0.05 1 "falling")))
    errset(mtxDump("/home/mseminario2/vestarv/implementations/asic/castalia/analog/data/raw/drive_map__fs63__idd_q.csv" value(abs(i("/POWER/SRC_VDD25/PLUS")) 0.0)))
    errset(mtxDump("/home/mseminario2/vestarv/implementations/asic/castalia/analog/data/raw/drive_map__fs63__rout.csv" abs((value(v("/V_OutOL") 0.5e-6)-value(v("/V_OutOL") -0.5e-6))/1e-6)))
    errset(mtxDump("/home/mseminario2/vestarv/implementations/asic/castalia/analog/data/raw/drive_map__fs63__verr.csv" (v("/V_OutOL")-v("/V_InP"))))
    errset(mtxDump("/home/mseminario2/vestarv/implementations/asic/castalia/analog/data/raw/drive_map__fs63__verr_q.csv" value((v("/V_OutOL")-v("/V_InP")) 0.0)))
  )
)

;; ---- corner 64 (sf64) / test drive_map
when(isDir("/home/mseminario2/chips/castalia/simarchive/anatop_tb_controlamp/Interactive.137/64/DriveMapTB/psf")
  openResults("/home/mseminario2/chips/castalia/simarchive/anatop_tb_controlamp/Interactive.137/64/DriveMapTB/psf")
  when(member('dc results())
    selectResult('dc)
    mtxP = outfile("/home/mseminario2/vestarv/implementations/asic/castalia/analog/data/raw/drive_map__sf64.meta" "w")
    fprintf(mtxP "sweep %%L\n" car(errset(sweepNames())))
    close(mtxP)
    errset(mtxDump("/home/mseminario2/vestarv/implementations/asic/castalia/analog/data/raw/drive_map__sf64__i_sink.csv" cross((v("/V_OutOL")-v("/V_InP")) 0.05 1 "falling")))
    errset(mtxDump("/home/mseminario2/vestarv/implementations/asic/castalia/analog/data/raw/drive_map__sf64__i_span.csv" (cross((v("/V_OutOL")-v("/V_InP")) -0.05 1 "falling")-cross((v("/V_OutOL")-v("/V_InP")) 0.05 1 "falling"))))
    errset(mtxDump("/home/mseminario2/vestarv/implementations/asic/castalia/analog/data/raw/drive_map__sf64__i_src.csv" cross((v("/V_OutOL")-v("/V_InP")) -0.05 1 "falling")))
    errset(mtxDump("/home/mseminario2/vestarv/implementations/asic/castalia/analog/data/raw/drive_map__sf64__idd_q.csv" value(abs(i("/POWER/SRC_VDD25/PLUS")) 0.0)))
    errset(mtxDump("/home/mseminario2/vestarv/implementations/asic/castalia/analog/data/raw/drive_map__sf64__rout.csv" abs((value(v("/V_OutOL") 0.5e-6)-value(v("/V_OutOL") -0.5e-6))/1e-6)))
    errset(mtxDump("/home/mseminario2/vestarv/implementations/asic/castalia/analog/data/raw/drive_map__sf64__verr.csv" (v("/V_OutOL")-v("/V_InP"))))
    errset(mtxDump("/home/mseminario2/vestarv/implementations/asic/castalia/analog/data/raw/drive_map__sf64__verr_q.csv" value((v("/V_OutOL")-v("/V_InP")) 0.0)))
  )
)

;; ---- corner 65 (ss65) / test drive_map
when(isDir("/home/mseminario2/chips/castalia/simarchive/anatop_tb_controlamp/Interactive.137/65/DriveMapTB/psf")
  openResults("/home/mseminario2/chips/castalia/simarchive/anatop_tb_controlamp/Interactive.137/65/DriveMapTB/psf")
  when(member('dc results())
    selectResult('dc)
    mtxP = outfile("/home/mseminario2/vestarv/implementations/asic/castalia/analog/data/raw/drive_map__ss65.meta" "w")
    fprintf(mtxP "sweep %%L\n" car(errset(sweepNames())))
    close(mtxP)
    errset(mtxDump("/home/mseminario2/vestarv/implementations/asic/castalia/analog/data/raw/drive_map__ss65__i_sink.csv" cross((v("/V_OutOL")-v("/V_InP")) 0.05 1 "falling")))
    errset(mtxDump("/home/mseminario2/vestarv/implementations/asic/castalia/analog/data/raw/drive_map__ss65__i_span.csv" (cross((v("/V_OutOL")-v("/V_InP")) -0.05 1 "falling")-cross((v("/V_OutOL")-v("/V_InP")) 0.05 1 "falling"))))
    errset(mtxDump("/home/mseminario2/vestarv/implementations/asic/castalia/analog/data/raw/drive_map__ss65__i_src.csv" cross((v("/V_OutOL")-v("/V_InP")) -0.05 1 "falling")))
    errset(mtxDump("/home/mseminario2/vestarv/implementations/asic/castalia/analog/data/raw/drive_map__ss65__idd_q.csv" value(abs(i("/POWER/SRC_VDD25/PLUS")) 0.0)))
    errset(mtxDump("/home/mseminario2/vestarv/implementations/asic/castalia/analog/data/raw/drive_map__ss65__rout.csv" abs((value(v("/V_OutOL") 0.5e-6)-value(v("/V_OutOL") -0.5e-6))/1e-6)))
    errset(mtxDump("/home/mseminario2/vestarv/implementations/asic/castalia/analog/data/raw/drive_map__ss65__verr.csv" (v("/V_OutOL")-v("/V_InP"))))
    errset(mtxDump("/home/mseminario2/vestarv/implementations/asic/castalia/analog/data/raw/drive_map__ss65__verr_q.csv" value((v("/V_OutOL")-v("/V_InP")) 0.0)))
  )
)

;; ---- corner 66 (tt66) / test drive_map
when(isDir("/home/mseminario2/chips/castalia/simarchive/anatop_tb_controlamp/Interactive.137/66/DriveMapTB/psf")
  openResults("/home/mseminario2/chips/castalia/simarchive/anatop_tb_controlamp/Interactive.137/66/DriveMapTB/psf")
  when(member('dc results())
    selectResult('dc)
    mtxP = outfile("/home/mseminario2/vestarv/implementations/asic/castalia/analog/data/raw/drive_map__tt66.meta" "w")
    fprintf(mtxP "sweep %%L\n" car(errset(sweepNames())))
    close(mtxP)
    errset(mtxDump("/home/mseminario2/vestarv/implementations/asic/castalia/analog/data/raw/drive_map__tt66__i_sink.csv" cross((v("/V_OutOL")-v("/V_InP")) 0.05 1 "falling")))
    errset(mtxDump("/home/mseminario2/vestarv/implementations/asic/castalia/analog/data/raw/drive_map__tt66__i_span.csv" (cross((v("/V_OutOL")-v("/V_InP")) -0.05 1 "falling")-cross((v("/V_OutOL")-v("/V_InP")) 0.05 1 "falling"))))
    errset(mtxDump("/home/mseminario2/vestarv/implementations/asic/castalia/analog/data/raw/drive_map__tt66__i_src.csv" cross((v("/V_OutOL")-v("/V_InP")) -0.05 1 "falling")))
    errset(mtxDump("/home/mseminario2/vestarv/implementations/asic/castalia/analog/data/raw/drive_map__tt66__idd_q.csv" value(abs(i("/POWER/SRC_VDD25/PLUS")) 0.0)))
    errset(mtxDump("/home/mseminario2/vestarv/implementations/asic/castalia/analog/data/raw/drive_map__tt66__rout.csv" abs((value(v("/V_OutOL") 0.5e-6)-value(v("/V_OutOL") -0.5e-6))/1e-6)))
    errset(mtxDump("/home/mseminario2/vestarv/implementations/asic/castalia/analog/data/raw/drive_map__tt66__verr.csv" (v("/V_OutOL")-v("/V_InP"))))
    errset(mtxDump("/home/mseminario2/vestarv/implementations/asic/castalia/analog/data/raw/drive_map__tt66__verr_q.csv" value((v("/V_OutOL")-v("/V_InP")) 0.0)))
  )
)

;; ---- corner 67 (ff67) / test drive_map
when(isDir("/home/mseminario2/chips/castalia/simarchive/anatop_tb_controlamp/Interactive.137/67/DriveMapTB/psf")
  openResults("/home/mseminario2/chips/castalia/simarchive/anatop_tb_controlamp/Interactive.137/67/DriveMapTB/psf")
  when(member('dc results())
    selectResult('dc)
    mtxP = outfile("/home/mseminario2/vestarv/implementations/asic/castalia/analog/data/raw/drive_map__ff67.meta" "w")
    fprintf(mtxP "sweep %%L\n" car(errset(sweepNames())))
    close(mtxP)
    errset(mtxDump("/home/mseminario2/vestarv/implementations/asic/castalia/analog/data/raw/drive_map__ff67__i_sink.csv" cross((v("/V_OutOL")-v("/V_InP")) 0.05 1 "falling")))
    errset(mtxDump("/home/mseminario2/vestarv/implementations/asic/castalia/analog/data/raw/drive_map__ff67__i_span.csv" (cross((v("/V_OutOL")-v("/V_InP")) -0.05 1 "falling")-cross((v("/V_OutOL")-v("/V_InP")) 0.05 1 "falling"))))
    errset(mtxDump("/home/mseminario2/vestarv/implementations/asic/castalia/analog/data/raw/drive_map__ff67__i_src.csv" cross((v("/V_OutOL")-v("/V_InP")) -0.05 1 "falling")))
    errset(mtxDump("/home/mseminario2/vestarv/implementations/asic/castalia/analog/data/raw/drive_map__ff67__idd_q.csv" value(abs(i("/POWER/SRC_VDD25/PLUS")) 0.0)))
    errset(mtxDump("/home/mseminario2/vestarv/implementations/asic/castalia/analog/data/raw/drive_map__ff67__rout.csv" abs((value(v("/V_OutOL") 0.5e-6)-value(v("/V_OutOL") -0.5e-6))/1e-6)))
    errset(mtxDump("/home/mseminario2/vestarv/implementations/asic/castalia/analog/data/raw/drive_map__ff67__verr.csv" (v("/V_OutOL")-v("/V_InP"))))
    errset(mtxDump("/home/mseminario2/vestarv/implementations/asic/castalia/analog/data/raw/drive_map__ff67__verr_q.csv" value((v("/V_OutOL")-v("/V_InP")) 0.0)))
  )
)

;; ---- corner 68 (fs68) / test drive_map
when(isDir("/home/mseminario2/chips/castalia/simarchive/anatop_tb_controlamp/Interactive.137/68/DriveMapTB/psf")
  openResults("/home/mseminario2/chips/castalia/simarchive/anatop_tb_controlamp/Interactive.137/68/DriveMapTB/psf")
  when(member('dc results())
    selectResult('dc)
    mtxP = outfile("/home/mseminario2/vestarv/implementations/asic/castalia/analog/data/raw/drive_map__fs68.meta" "w")
    fprintf(mtxP "sweep %%L\n" car(errset(sweepNames())))
    close(mtxP)
    errset(mtxDump("/home/mseminario2/vestarv/implementations/asic/castalia/analog/data/raw/drive_map__fs68__i_sink.csv" cross((v("/V_OutOL")-v("/V_InP")) 0.05 1 "falling")))
    errset(mtxDump("/home/mseminario2/vestarv/implementations/asic/castalia/analog/data/raw/drive_map__fs68__i_span.csv" (cross((v("/V_OutOL")-v("/V_InP")) -0.05 1 "falling")-cross((v("/V_OutOL")-v("/V_InP")) 0.05 1 "falling"))))
    errset(mtxDump("/home/mseminario2/vestarv/implementations/asic/castalia/analog/data/raw/drive_map__fs68__i_src.csv" cross((v("/V_OutOL")-v("/V_InP")) -0.05 1 "falling")))
    errset(mtxDump("/home/mseminario2/vestarv/implementations/asic/castalia/analog/data/raw/drive_map__fs68__idd_q.csv" value(abs(i("/POWER/SRC_VDD25/PLUS")) 0.0)))
    errset(mtxDump("/home/mseminario2/vestarv/implementations/asic/castalia/analog/data/raw/drive_map__fs68__rout.csv" abs((value(v("/V_OutOL") 0.5e-6)-value(v("/V_OutOL") -0.5e-6))/1e-6)))
    errset(mtxDump("/home/mseminario2/vestarv/implementations/asic/castalia/analog/data/raw/drive_map__fs68__verr.csv" (v("/V_OutOL")-v("/V_InP"))))
    errset(mtxDump("/home/mseminario2/vestarv/implementations/asic/castalia/analog/data/raw/drive_map__fs68__verr_q.csv" value((v("/V_OutOL")-v("/V_InP")) 0.0)))
  )
)

;; ---- corner 69 (sf69) / test drive_map
when(isDir("/home/mseminario2/chips/castalia/simarchive/anatop_tb_controlamp/Interactive.137/69/DriveMapTB/psf")
  openResults("/home/mseminario2/chips/castalia/simarchive/anatop_tb_controlamp/Interactive.137/69/DriveMapTB/psf")
  when(member('dc results())
    selectResult('dc)
    mtxP = outfile("/home/mseminario2/vestarv/implementations/asic/castalia/analog/data/raw/drive_map__sf69.meta" "w")
    fprintf(mtxP "sweep %%L\n" car(errset(sweepNames())))
    close(mtxP)
    errset(mtxDump("/home/mseminario2/vestarv/implementations/asic/castalia/analog/data/raw/drive_map__sf69__i_sink.csv" cross((v("/V_OutOL")-v("/V_InP")) 0.05 1 "falling")))
    errset(mtxDump("/home/mseminario2/vestarv/implementations/asic/castalia/analog/data/raw/drive_map__sf69__i_span.csv" (cross((v("/V_OutOL")-v("/V_InP")) -0.05 1 "falling")-cross((v("/V_OutOL")-v("/V_InP")) 0.05 1 "falling"))))
    errset(mtxDump("/home/mseminario2/vestarv/implementations/asic/castalia/analog/data/raw/drive_map__sf69__i_src.csv" cross((v("/V_OutOL")-v("/V_InP")) -0.05 1 "falling")))
    errset(mtxDump("/home/mseminario2/vestarv/implementations/asic/castalia/analog/data/raw/drive_map__sf69__idd_q.csv" value(abs(i("/POWER/SRC_VDD25/PLUS")) 0.0)))
    errset(mtxDump("/home/mseminario2/vestarv/implementations/asic/castalia/analog/data/raw/drive_map__sf69__rout.csv" abs((value(v("/V_OutOL") 0.5e-6)-value(v("/V_OutOL") -0.5e-6))/1e-6)))
    errset(mtxDump("/home/mseminario2/vestarv/implementations/asic/castalia/analog/data/raw/drive_map__sf69__verr.csv" (v("/V_OutOL")-v("/V_InP"))))
    errset(mtxDump("/home/mseminario2/vestarv/implementations/asic/castalia/analog/data/raw/drive_map__sf69__verr_q.csv" value((v("/V_OutOL")-v("/V_InP")) 0.0)))
  )
)

;; ---- corner 70 (ss70) / test drive_map
when(isDir("/home/mseminario2/chips/castalia/simarchive/anatop_tb_controlamp/Interactive.137/70/DriveMapTB/psf")
  openResults("/home/mseminario2/chips/castalia/simarchive/anatop_tb_controlamp/Interactive.137/70/DriveMapTB/psf")
  when(member('dc results())
    selectResult('dc)
    mtxP = outfile("/home/mseminario2/vestarv/implementations/asic/castalia/analog/data/raw/drive_map__ss70.meta" "w")
    fprintf(mtxP "sweep %%L\n" car(errset(sweepNames())))
    close(mtxP)
    errset(mtxDump("/home/mseminario2/vestarv/implementations/asic/castalia/analog/data/raw/drive_map__ss70__i_sink.csv" cross((v("/V_OutOL")-v("/V_InP")) 0.05 1 "falling")))
    errset(mtxDump("/home/mseminario2/vestarv/implementations/asic/castalia/analog/data/raw/drive_map__ss70__i_span.csv" (cross((v("/V_OutOL")-v("/V_InP")) -0.05 1 "falling")-cross((v("/V_OutOL")-v("/V_InP")) 0.05 1 "falling"))))
    errset(mtxDump("/home/mseminario2/vestarv/implementations/asic/castalia/analog/data/raw/drive_map__ss70__i_src.csv" cross((v("/V_OutOL")-v("/V_InP")) -0.05 1 "falling")))
    errset(mtxDump("/home/mseminario2/vestarv/implementations/asic/castalia/analog/data/raw/drive_map__ss70__idd_q.csv" value(abs(i("/POWER/SRC_VDD25/PLUS")) 0.0)))
    errset(mtxDump("/home/mseminario2/vestarv/implementations/asic/castalia/analog/data/raw/drive_map__ss70__rout.csv" abs((value(v("/V_OutOL") 0.5e-6)-value(v("/V_OutOL") -0.5e-6))/1e-6)))
    errset(mtxDump("/home/mseminario2/vestarv/implementations/asic/castalia/analog/data/raw/drive_map__ss70__verr.csv" (v("/V_OutOL")-v("/V_InP"))))
    errset(mtxDump("/home/mseminario2/vestarv/implementations/asic/castalia/analog/data/raw/drive_map__ss70__verr_q.csv" value((v("/V_OutOL")-v("/V_InP")) 0.0)))
  )
)

;; ---- corner 71 (tt71) / test drive_map
when(isDir("/home/mseminario2/chips/castalia/simarchive/anatop_tb_controlamp/Interactive.137/71/DriveMapTB/psf")
  openResults("/home/mseminario2/chips/castalia/simarchive/anatop_tb_controlamp/Interactive.137/71/DriveMapTB/psf")
  when(member('dc results())
    selectResult('dc)
    mtxP = outfile("/home/mseminario2/vestarv/implementations/asic/castalia/analog/data/raw/drive_map__tt71.meta" "w")
    fprintf(mtxP "sweep %%L\n" car(errset(sweepNames())))
    close(mtxP)
    errset(mtxDump("/home/mseminario2/vestarv/implementations/asic/castalia/analog/data/raw/drive_map__tt71__i_sink.csv" cross((v("/V_OutOL")-v("/V_InP")) 0.05 1 "falling")))
    errset(mtxDump("/home/mseminario2/vestarv/implementations/asic/castalia/analog/data/raw/drive_map__tt71__i_span.csv" (cross((v("/V_OutOL")-v("/V_InP")) -0.05 1 "falling")-cross((v("/V_OutOL")-v("/V_InP")) 0.05 1 "falling"))))
    errset(mtxDump("/home/mseminario2/vestarv/implementations/asic/castalia/analog/data/raw/drive_map__tt71__i_src.csv" cross((v("/V_OutOL")-v("/V_InP")) -0.05 1 "falling")))
    errset(mtxDump("/home/mseminario2/vestarv/implementations/asic/castalia/analog/data/raw/drive_map__tt71__idd_q.csv" value(abs(i("/POWER/SRC_VDD25/PLUS")) 0.0)))
    errset(mtxDump("/home/mseminario2/vestarv/implementations/asic/castalia/analog/data/raw/drive_map__tt71__rout.csv" abs((value(v("/V_OutOL") 0.5e-6)-value(v("/V_OutOL") -0.5e-6))/1e-6)))
    errset(mtxDump("/home/mseminario2/vestarv/implementations/asic/castalia/analog/data/raw/drive_map__tt71__verr.csv" (v("/V_OutOL")-v("/V_InP"))))
    errset(mtxDump("/home/mseminario2/vestarv/implementations/asic/castalia/analog/data/raw/drive_map__tt71__verr_q.csv" value((v("/V_OutOL")-v("/V_InP")) 0.0)))
  )
)

;; ---- corner 72 (ff72) / test drive_map
when(isDir("/home/mseminario2/chips/castalia/simarchive/anatop_tb_controlamp/Interactive.137/72/DriveMapTB/psf")
  openResults("/home/mseminario2/chips/castalia/simarchive/anatop_tb_controlamp/Interactive.137/72/DriveMapTB/psf")
  when(member('dc results())
    selectResult('dc)
    mtxP = outfile("/home/mseminario2/vestarv/implementations/asic/castalia/analog/data/raw/drive_map__ff72.meta" "w")
    fprintf(mtxP "sweep %%L\n" car(errset(sweepNames())))
    close(mtxP)
    errset(mtxDump("/home/mseminario2/vestarv/implementations/asic/castalia/analog/data/raw/drive_map__ff72__i_sink.csv" cross((v("/V_OutOL")-v("/V_InP")) 0.05 1 "falling")))
    errset(mtxDump("/home/mseminario2/vestarv/implementations/asic/castalia/analog/data/raw/drive_map__ff72__i_span.csv" (cross((v("/V_OutOL")-v("/V_InP")) -0.05 1 "falling")-cross((v("/V_OutOL")-v("/V_InP")) 0.05 1 "falling"))))
    errset(mtxDump("/home/mseminario2/vestarv/implementations/asic/castalia/analog/data/raw/drive_map__ff72__i_src.csv" cross((v("/V_OutOL")-v("/V_InP")) -0.05 1 "falling")))
    errset(mtxDump("/home/mseminario2/vestarv/implementations/asic/castalia/analog/data/raw/drive_map__ff72__idd_q.csv" value(abs(i("/POWER/SRC_VDD25/PLUS")) 0.0)))
    errset(mtxDump("/home/mseminario2/vestarv/implementations/asic/castalia/analog/data/raw/drive_map__ff72__rout.csv" abs((value(v("/V_OutOL") 0.5e-6)-value(v("/V_OutOL") -0.5e-6))/1e-6)))
    errset(mtxDump("/home/mseminario2/vestarv/implementations/asic/castalia/analog/data/raw/drive_map__ff72__verr.csv" (v("/V_OutOL")-v("/V_InP"))))
    errset(mtxDump("/home/mseminario2/vestarv/implementations/asic/castalia/analog/data/raw/drive_map__ff72__verr_q.csv" value((v("/V_OutOL")-v("/V_InP")) 0.0)))
  )
)

;; ---- corner 73 (fs73) / test drive_map
when(isDir("/home/mseminario2/chips/castalia/simarchive/anatop_tb_controlamp/Interactive.137/73/DriveMapTB/psf")
  openResults("/home/mseminario2/chips/castalia/simarchive/anatop_tb_controlamp/Interactive.137/73/DriveMapTB/psf")
  when(member('dc results())
    selectResult('dc)
    mtxP = outfile("/home/mseminario2/vestarv/implementations/asic/castalia/analog/data/raw/drive_map__fs73.meta" "w")
    fprintf(mtxP "sweep %%L\n" car(errset(sweepNames())))
    close(mtxP)
    errset(mtxDump("/home/mseminario2/vestarv/implementations/asic/castalia/analog/data/raw/drive_map__fs73__i_sink.csv" cross((v("/V_OutOL")-v("/V_InP")) 0.05 1 "falling")))
    errset(mtxDump("/home/mseminario2/vestarv/implementations/asic/castalia/analog/data/raw/drive_map__fs73__i_span.csv" (cross((v("/V_OutOL")-v("/V_InP")) -0.05 1 "falling")-cross((v("/V_OutOL")-v("/V_InP")) 0.05 1 "falling"))))
    errset(mtxDump("/home/mseminario2/vestarv/implementations/asic/castalia/analog/data/raw/drive_map__fs73__i_src.csv" cross((v("/V_OutOL")-v("/V_InP")) -0.05 1 "falling")))
    errset(mtxDump("/home/mseminario2/vestarv/implementations/asic/castalia/analog/data/raw/drive_map__fs73__idd_q.csv" value(abs(i("/POWER/SRC_VDD25/PLUS")) 0.0)))
    errset(mtxDump("/home/mseminario2/vestarv/implementations/asic/castalia/analog/data/raw/drive_map__fs73__rout.csv" abs((value(v("/V_OutOL") 0.5e-6)-value(v("/V_OutOL") -0.5e-6))/1e-6)))
    errset(mtxDump("/home/mseminario2/vestarv/implementations/asic/castalia/analog/data/raw/drive_map__fs73__verr.csv" (v("/V_OutOL")-v("/V_InP"))))
    errset(mtxDump("/home/mseminario2/vestarv/implementations/asic/castalia/analog/data/raw/drive_map__fs73__verr_q.csv" value((v("/V_OutOL")-v("/V_InP")) 0.0)))
  )
)

;; ---- corner 74 (sf74) / test drive_map
when(isDir("/home/mseminario2/chips/castalia/simarchive/anatop_tb_controlamp/Interactive.137/74/DriveMapTB/psf")
  openResults("/home/mseminario2/chips/castalia/simarchive/anatop_tb_controlamp/Interactive.137/74/DriveMapTB/psf")
  when(member('dc results())
    selectResult('dc)
    mtxP = outfile("/home/mseminario2/vestarv/implementations/asic/castalia/analog/data/raw/drive_map__sf74.meta" "w")
    fprintf(mtxP "sweep %%L\n" car(errset(sweepNames())))
    close(mtxP)
    errset(mtxDump("/home/mseminario2/vestarv/implementations/asic/castalia/analog/data/raw/drive_map__sf74__i_sink.csv" cross((v("/V_OutOL")-v("/V_InP")) 0.05 1 "falling")))
    errset(mtxDump("/home/mseminario2/vestarv/implementations/asic/castalia/analog/data/raw/drive_map__sf74__i_span.csv" (cross((v("/V_OutOL")-v("/V_InP")) -0.05 1 "falling")-cross((v("/V_OutOL")-v("/V_InP")) 0.05 1 "falling"))))
    errset(mtxDump("/home/mseminario2/vestarv/implementations/asic/castalia/analog/data/raw/drive_map__sf74__i_src.csv" cross((v("/V_OutOL")-v("/V_InP")) -0.05 1 "falling")))
    errset(mtxDump("/home/mseminario2/vestarv/implementations/asic/castalia/analog/data/raw/drive_map__sf74__idd_q.csv" value(abs(i("/POWER/SRC_VDD25/PLUS")) 0.0)))
    errset(mtxDump("/home/mseminario2/vestarv/implementations/asic/castalia/analog/data/raw/drive_map__sf74__rout.csv" abs((value(v("/V_OutOL") 0.5e-6)-value(v("/V_OutOL") -0.5e-6))/1e-6)))
    errset(mtxDump("/home/mseminario2/vestarv/implementations/asic/castalia/analog/data/raw/drive_map__sf74__verr.csv" (v("/V_OutOL")-v("/V_InP"))))
    errset(mtxDump("/home/mseminario2/vestarv/implementations/asic/castalia/analog/data/raw/drive_map__sf74__verr_q.csv" value((v("/V_OutOL")-v("/V_InP")) 0.0)))
  )
)

;; ---- corner 75 (ss75) / test drive_map
when(isDir("/home/mseminario2/chips/castalia/simarchive/anatop_tb_controlamp/Interactive.137/75/DriveMapTB/psf")
  openResults("/home/mseminario2/chips/castalia/simarchive/anatop_tb_controlamp/Interactive.137/75/DriveMapTB/psf")
  when(member('dc results())
    selectResult('dc)
    mtxP = outfile("/home/mseminario2/vestarv/implementations/asic/castalia/analog/data/raw/drive_map__ss75.meta" "w")
    fprintf(mtxP "sweep %%L\n" car(errset(sweepNames())))
    close(mtxP)
    errset(mtxDump("/home/mseminario2/vestarv/implementations/asic/castalia/analog/data/raw/drive_map__ss75__i_sink.csv" cross((v("/V_OutOL")-v("/V_InP")) 0.05 1 "falling")))
    errset(mtxDump("/home/mseminario2/vestarv/implementations/asic/castalia/analog/data/raw/drive_map__ss75__i_span.csv" (cross((v("/V_OutOL")-v("/V_InP")) -0.05 1 "falling")-cross((v("/V_OutOL")-v("/V_InP")) 0.05 1 "falling"))))
    errset(mtxDump("/home/mseminario2/vestarv/implementations/asic/castalia/analog/data/raw/drive_map__ss75__i_src.csv" cross((v("/V_OutOL")-v("/V_InP")) -0.05 1 "falling")))
    errset(mtxDump("/home/mseminario2/vestarv/implementations/asic/castalia/analog/data/raw/drive_map__ss75__idd_q.csv" value(abs(i("/POWER/SRC_VDD25/PLUS")) 0.0)))
    errset(mtxDump("/home/mseminario2/vestarv/implementations/asic/castalia/analog/data/raw/drive_map__ss75__rout.csv" abs((value(v("/V_OutOL") 0.5e-6)-value(v("/V_OutOL") -0.5e-6))/1e-6)))
    errset(mtxDump("/home/mseminario2/vestarv/implementations/asic/castalia/analog/data/raw/drive_map__ss75__verr.csv" (v("/V_OutOL")-v("/V_InP"))))
    errset(mtxDump("/home/mseminario2/vestarv/implementations/asic/castalia/analog/data/raw/drive_map__ss75__verr_q.csv" value((v("/V_OutOL")-v("/V_InP")) 0.0)))
  )
)

;; ---- corner 76 (tt76) / test drive_map
when(isDir("/home/mseminario2/chips/castalia/simarchive/anatop_tb_controlamp/Interactive.137/76/DriveMapTB/psf")
  openResults("/home/mseminario2/chips/castalia/simarchive/anatop_tb_controlamp/Interactive.137/76/DriveMapTB/psf")
  when(member('dc results())
    selectResult('dc)
    mtxP = outfile("/home/mseminario2/vestarv/implementations/asic/castalia/analog/data/raw/drive_map__tt76.meta" "w")
    fprintf(mtxP "sweep %%L\n" car(errset(sweepNames())))
    close(mtxP)
    errset(mtxDump("/home/mseminario2/vestarv/implementations/asic/castalia/analog/data/raw/drive_map__tt76__i_sink.csv" cross((v("/V_OutOL")-v("/V_InP")) 0.05 1 "falling")))
    errset(mtxDump("/home/mseminario2/vestarv/implementations/asic/castalia/analog/data/raw/drive_map__tt76__i_span.csv" (cross((v("/V_OutOL")-v("/V_InP")) -0.05 1 "falling")-cross((v("/V_OutOL")-v("/V_InP")) 0.05 1 "falling"))))
    errset(mtxDump("/home/mseminario2/vestarv/implementations/asic/castalia/analog/data/raw/drive_map__tt76__i_src.csv" cross((v("/V_OutOL")-v("/V_InP")) -0.05 1 "falling")))
    errset(mtxDump("/home/mseminario2/vestarv/implementations/asic/castalia/analog/data/raw/drive_map__tt76__idd_q.csv" value(abs(i("/POWER/SRC_VDD25/PLUS")) 0.0)))
    errset(mtxDump("/home/mseminario2/vestarv/implementations/asic/castalia/analog/data/raw/drive_map__tt76__rout.csv" abs((value(v("/V_OutOL") 0.5e-6)-value(v("/V_OutOL") -0.5e-6))/1e-6)))
    errset(mtxDump("/home/mseminario2/vestarv/implementations/asic/castalia/analog/data/raw/drive_map__tt76__verr.csv" (v("/V_OutOL")-v("/V_InP"))))
    errset(mtxDump("/home/mseminario2/vestarv/implementations/asic/castalia/analog/data/raw/drive_map__tt76__verr_q.csv" value((v("/V_OutOL")-v("/V_InP")) 0.0)))
  )
)

;; ---- corner 77 (ff77) / test drive_map
when(isDir("/home/mseminario2/chips/castalia/simarchive/anatop_tb_controlamp/Interactive.137/77/DriveMapTB/psf")
  openResults("/home/mseminario2/chips/castalia/simarchive/anatop_tb_controlamp/Interactive.137/77/DriveMapTB/psf")
  when(member('dc results())
    selectResult('dc)
    mtxP = outfile("/home/mseminario2/vestarv/implementations/asic/castalia/analog/data/raw/drive_map__ff77.meta" "w")
    fprintf(mtxP "sweep %%L\n" car(errset(sweepNames())))
    close(mtxP)
    errset(mtxDump("/home/mseminario2/vestarv/implementations/asic/castalia/analog/data/raw/drive_map__ff77__i_sink.csv" cross((v("/V_OutOL")-v("/V_InP")) 0.05 1 "falling")))
    errset(mtxDump("/home/mseminario2/vestarv/implementations/asic/castalia/analog/data/raw/drive_map__ff77__i_span.csv" (cross((v("/V_OutOL")-v("/V_InP")) -0.05 1 "falling")-cross((v("/V_OutOL")-v("/V_InP")) 0.05 1 "falling"))))
    errset(mtxDump("/home/mseminario2/vestarv/implementations/asic/castalia/analog/data/raw/drive_map__ff77__i_src.csv" cross((v("/V_OutOL")-v("/V_InP")) -0.05 1 "falling")))
    errset(mtxDump("/home/mseminario2/vestarv/implementations/asic/castalia/analog/data/raw/drive_map__ff77__idd_q.csv" value(abs(i("/POWER/SRC_VDD25/PLUS")) 0.0)))
    errset(mtxDump("/home/mseminario2/vestarv/implementations/asic/castalia/analog/data/raw/drive_map__ff77__rout.csv" abs((value(v("/V_OutOL") 0.5e-6)-value(v("/V_OutOL") -0.5e-6))/1e-6)))
    errset(mtxDump("/home/mseminario2/vestarv/implementations/asic/castalia/analog/data/raw/drive_map__ff77__verr.csv" (v("/V_OutOL")-v("/V_InP"))))
    errset(mtxDump("/home/mseminario2/vestarv/implementations/asic/castalia/analog/data/raw/drive_map__ff77__verr_q.csv" value((v("/V_OutOL")-v("/V_InP")) 0.0)))
  )
)

;; ---- corner 78 (fs78) / test drive_map
when(isDir("/home/mseminario2/chips/castalia/simarchive/anatop_tb_controlamp/Interactive.137/78/DriveMapTB/psf")
  openResults("/home/mseminario2/chips/castalia/simarchive/anatop_tb_controlamp/Interactive.137/78/DriveMapTB/psf")
  when(member('dc results())
    selectResult('dc)
    mtxP = outfile("/home/mseminario2/vestarv/implementations/asic/castalia/analog/data/raw/drive_map__fs78.meta" "w")
    fprintf(mtxP "sweep %%L\n" car(errset(sweepNames())))
    close(mtxP)
    errset(mtxDump("/home/mseminario2/vestarv/implementations/asic/castalia/analog/data/raw/drive_map__fs78__i_sink.csv" cross((v("/V_OutOL")-v("/V_InP")) 0.05 1 "falling")))
    errset(mtxDump("/home/mseminario2/vestarv/implementations/asic/castalia/analog/data/raw/drive_map__fs78__i_span.csv" (cross((v("/V_OutOL")-v("/V_InP")) -0.05 1 "falling")-cross((v("/V_OutOL")-v("/V_InP")) 0.05 1 "falling"))))
    errset(mtxDump("/home/mseminario2/vestarv/implementations/asic/castalia/analog/data/raw/drive_map__fs78__i_src.csv" cross((v("/V_OutOL")-v("/V_InP")) -0.05 1 "falling")))
    errset(mtxDump("/home/mseminario2/vestarv/implementations/asic/castalia/analog/data/raw/drive_map__fs78__idd_q.csv" value(abs(i("/POWER/SRC_VDD25/PLUS")) 0.0)))
    errset(mtxDump("/home/mseminario2/vestarv/implementations/asic/castalia/analog/data/raw/drive_map__fs78__rout.csv" abs((value(v("/V_OutOL") 0.5e-6)-value(v("/V_OutOL") -0.5e-6))/1e-6)))
    errset(mtxDump("/home/mseminario2/vestarv/implementations/asic/castalia/analog/data/raw/drive_map__fs78__verr.csv" (v("/V_OutOL")-v("/V_InP"))))
    errset(mtxDump("/home/mseminario2/vestarv/implementations/asic/castalia/analog/data/raw/drive_map__fs78__verr_q.csv" value((v("/V_OutOL")-v("/V_InP")) 0.0)))
  )
)

;; ---- corner 79 (sf79) / test drive_map
when(isDir("/home/mseminario2/chips/castalia/simarchive/anatop_tb_controlamp/Interactive.137/79/DriveMapTB/psf")
  openResults("/home/mseminario2/chips/castalia/simarchive/anatop_tb_controlamp/Interactive.137/79/DriveMapTB/psf")
  when(member('dc results())
    selectResult('dc)
    mtxP = outfile("/home/mseminario2/vestarv/implementations/asic/castalia/analog/data/raw/drive_map__sf79.meta" "w")
    fprintf(mtxP "sweep %%L\n" car(errset(sweepNames())))
    close(mtxP)
    errset(mtxDump("/home/mseminario2/vestarv/implementations/asic/castalia/analog/data/raw/drive_map__sf79__i_sink.csv" cross((v("/V_OutOL")-v("/V_InP")) 0.05 1 "falling")))
    errset(mtxDump("/home/mseminario2/vestarv/implementations/asic/castalia/analog/data/raw/drive_map__sf79__i_span.csv" (cross((v("/V_OutOL")-v("/V_InP")) -0.05 1 "falling")-cross((v("/V_OutOL")-v("/V_InP")) 0.05 1 "falling"))))
    errset(mtxDump("/home/mseminario2/vestarv/implementations/asic/castalia/analog/data/raw/drive_map__sf79__i_src.csv" cross((v("/V_OutOL")-v("/V_InP")) -0.05 1 "falling")))
    errset(mtxDump("/home/mseminario2/vestarv/implementations/asic/castalia/analog/data/raw/drive_map__sf79__idd_q.csv" value(abs(i("/POWER/SRC_VDD25/PLUS")) 0.0)))
    errset(mtxDump("/home/mseminario2/vestarv/implementations/asic/castalia/analog/data/raw/drive_map__sf79__rout.csv" abs((value(v("/V_OutOL") 0.5e-6)-value(v("/V_OutOL") -0.5e-6))/1e-6)))
    errset(mtxDump("/home/mseminario2/vestarv/implementations/asic/castalia/analog/data/raw/drive_map__sf79__verr.csv" (v("/V_OutOL")-v("/V_InP"))))
    errset(mtxDump("/home/mseminario2/vestarv/implementations/asic/castalia/analog/data/raw/drive_map__sf79__verr_q.csv" value((v("/V_OutOL")-v("/V_InP")) 0.0)))
  )
)

;; ---- corner 80 (ss80) / test drive_map
when(isDir("/home/mseminario2/chips/castalia/simarchive/anatop_tb_controlamp/Interactive.137/80/DriveMapTB/psf")
  openResults("/home/mseminario2/chips/castalia/simarchive/anatop_tb_controlamp/Interactive.137/80/DriveMapTB/psf")
  when(member('dc results())
    selectResult('dc)
    mtxP = outfile("/home/mseminario2/vestarv/implementations/asic/castalia/analog/data/raw/drive_map__ss80.meta" "w")
    fprintf(mtxP "sweep %%L\n" car(errset(sweepNames())))
    close(mtxP)
    errset(mtxDump("/home/mseminario2/vestarv/implementations/asic/castalia/analog/data/raw/drive_map__ss80__i_sink.csv" cross((v("/V_OutOL")-v("/V_InP")) 0.05 1 "falling")))
    errset(mtxDump("/home/mseminario2/vestarv/implementations/asic/castalia/analog/data/raw/drive_map__ss80__i_span.csv" (cross((v("/V_OutOL")-v("/V_InP")) -0.05 1 "falling")-cross((v("/V_OutOL")-v("/V_InP")) 0.05 1 "falling"))))
    errset(mtxDump("/home/mseminario2/vestarv/implementations/asic/castalia/analog/data/raw/drive_map__ss80__i_src.csv" cross((v("/V_OutOL")-v("/V_InP")) -0.05 1 "falling")))
    errset(mtxDump("/home/mseminario2/vestarv/implementations/asic/castalia/analog/data/raw/drive_map__ss80__idd_q.csv" value(abs(i("/POWER/SRC_VDD25/PLUS")) 0.0)))
    errset(mtxDump("/home/mseminario2/vestarv/implementations/asic/castalia/analog/data/raw/drive_map__ss80__rout.csv" abs((value(v("/V_OutOL") 0.5e-6)-value(v("/V_OutOL") -0.5e-6))/1e-6)))
    errset(mtxDump("/home/mseminario2/vestarv/implementations/asic/castalia/analog/data/raw/drive_map__ss80__verr.csv" (v("/V_OutOL")-v("/V_InP"))))
    errset(mtxDump("/home/mseminario2/vestarv/implementations/asic/castalia/analog/data/raw/drive_map__ss80__verr_q.csv" value((v("/V_OutOL")-v("/V_InP")) 0.0)))
  )
)

;; ---- corner 81 (tt81) / test drive_map
when(isDir("/home/mseminario2/chips/castalia/simarchive/anatop_tb_controlamp/Interactive.137/81/DriveMapTB/psf")
  openResults("/home/mseminario2/chips/castalia/simarchive/anatop_tb_controlamp/Interactive.137/81/DriveMapTB/psf")
  when(member('dc results())
    selectResult('dc)
    mtxP = outfile("/home/mseminario2/vestarv/implementations/asic/castalia/analog/data/raw/drive_map__tt81.meta" "w")
    fprintf(mtxP "sweep %%L\n" car(errset(sweepNames())))
    close(mtxP)
    errset(mtxDump("/home/mseminario2/vestarv/implementations/asic/castalia/analog/data/raw/drive_map__tt81__i_sink.csv" cross((v("/V_OutOL")-v("/V_InP")) 0.05 1 "falling")))
    errset(mtxDump("/home/mseminario2/vestarv/implementations/asic/castalia/analog/data/raw/drive_map__tt81__i_span.csv" (cross((v("/V_OutOL")-v("/V_InP")) -0.05 1 "falling")-cross((v("/V_OutOL")-v("/V_InP")) 0.05 1 "falling"))))
    errset(mtxDump("/home/mseminario2/vestarv/implementations/asic/castalia/analog/data/raw/drive_map__tt81__i_src.csv" cross((v("/V_OutOL")-v("/V_InP")) -0.05 1 "falling")))
    errset(mtxDump("/home/mseminario2/vestarv/implementations/asic/castalia/analog/data/raw/drive_map__tt81__idd_q.csv" value(abs(i("/POWER/SRC_VDD25/PLUS")) 0.0)))
    errset(mtxDump("/home/mseminario2/vestarv/implementations/asic/castalia/analog/data/raw/drive_map__tt81__rout.csv" abs((value(v("/V_OutOL") 0.5e-6)-value(v("/V_OutOL") -0.5e-6))/1e-6)))
    errset(mtxDump("/home/mseminario2/vestarv/implementations/asic/castalia/analog/data/raw/drive_map__tt81__verr.csv" (v("/V_OutOL")-v("/V_InP"))))
    errset(mtxDump("/home/mseminario2/vestarv/implementations/asic/castalia/analog/data/raw/drive_map__tt81__verr_q.csv" value((v("/V_OutOL")-v("/V_InP")) 0.0)))
  )
)

;; ---- corner 82 (ff82) / test drive_map
when(isDir("/home/mseminario2/chips/castalia/simarchive/anatop_tb_controlamp/Interactive.137/82/DriveMapTB/psf")
  openResults("/home/mseminario2/chips/castalia/simarchive/anatop_tb_controlamp/Interactive.137/82/DriveMapTB/psf")
  when(member('dc results())
    selectResult('dc)
    mtxP = outfile("/home/mseminario2/vestarv/implementations/asic/castalia/analog/data/raw/drive_map__ff82.meta" "w")
    fprintf(mtxP "sweep %%L\n" car(errset(sweepNames())))
    close(mtxP)
    errset(mtxDump("/home/mseminario2/vestarv/implementations/asic/castalia/analog/data/raw/drive_map__ff82__i_sink.csv" cross((v("/V_OutOL")-v("/V_InP")) 0.05 1 "falling")))
    errset(mtxDump("/home/mseminario2/vestarv/implementations/asic/castalia/analog/data/raw/drive_map__ff82__i_span.csv" (cross((v("/V_OutOL")-v("/V_InP")) -0.05 1 "falling")-cross((v("/V_OutOL")-v("/V_InP")) 0.05 1 "falling"))))
    errset(mtxDump("/home/mseminario2/vestarv/implementations/asic/castalia/analog/data/raw/drive_map__ff82__i_src.csv" cross((v("/V_OutOL")-v("/V_InP")) -0.05 1 "falling")))
    errset(mtxDump("/home/mseminario2/vestarv/implementations/asic/castalia/analog/data/raw/drive_map__ff82__idd_q.csv" value(abs(i("/POWER/SRC_VDD25/PLUS")) 0.0)))
    errset(mtxDump("/home/mseminario2/vestarv/implementations/asic/castalia/analog/data/raw/drive_map__ff82__rout.csv" abs((value(v("/V_OutOL") 0.5e-6)-value(v("/V_OutOL") -0.5e-6))/1e-6)))
    errset(mtxDump("/home/mseminario2/vestarv/implementations/asic/castalia/analog/data/raw/drive_map__ff82__verr.csv" (v("/V_OutOL")-v("/V_InP"))))
    errset(mtxDump("/home/mseminario2/vestarv/implementations/asic/castalia/analog/data/raw/drive_map__ff82__verr_q.csv" value((v("/V_OutOL")-v("/V_InP")) 0.0)))
  )
)

;; ---- corner 83 (fs83) / test drive_map
when(isDir("/home/mseminario2/chips/castalia/simarchive/anatop_tb_controlamp/Interactive.137/83/DriveMapTB/psf")
  openResults("/home/mseminario2/chips/castalia/simarchive/anatop_tb_controlamp/Interactive.137/83/DriveMapTB/psf")
  when(member('dc results())
    selectResult('dc)
    mtxP = outfile("/home/mseminario2/vestarv/implementations/asic/castalia/analog/data/raw/drive_map__fs83.meta" "w")
    fprintf(mtxP "sweep %%L\n" car(errset(sweepNames())))
    close(mtxP)
    errset(mtxDump("/home/mseminario2/vestarv/implementations/asic/castalia/analog/data/raw/drive_map__fs83__i_sink.csv" cross((v("/V_OutOL")-v("/V_InP")) 0.05 1 "falling")))
    errset(mtxDump("/home/mseminario2/vestarv/implementations/asic/castalia/analog/data/raw/drive_map__fs83__i_span.csv" (cross((v("/V_OutOL")-v("/V_InP")) -0.05 1 "falling")-cross((v("/V_OutOL")-v("/V_InP")) 0.05 1 "falling"))))
    errset(mtxDump("/home/mseminario2/vestarv/implementations/asic/castalia/analog/data/raw/drive_map__fs83__i_src.csv" cross((v("/V_OutOL")-v("/V_InP")) -0.05 1 "falling")))
    errset(mtxDump("/home/mseminario2/vestarv/implementations/asic/castalia/analog/data/raw/drive_map__fs83__idd_q.csv" value(abs(i("/POWER/SRC_VDD25/PLUS")) 0.0)))
    errset(mtxDump("/home/mseminario2/vestarv/implementations/asic/castalia/analog/data/raw/drive_map__fs83__rout.csv" abs((value(v("/V_OutOL") 0.5e-6)-value(v("/V_OutOL") -0.5e-6))/1e-6)))
    errset(mtxDump("/home/mseminario2/vestarv/implementations/asic/castalia/analog/data/raw/drive_map__fs83__verr.csv" (v("/V_OutOL")-v("/V_InP"))))
    errset(mtxDump("/home/mseminario2/vestarv/implementations/asic/castalia/analog/data/raw/drive_map__fs83__verr_q.csv" value((v("/V_OutOL")-v("/V_InP")) 0.0)))
  )
)

;; ---- corner 84 (sf84) / test drive_map
when(isDir("/home/mseminario2/chips/castalia/simarchive/anatop_tb_controlamp/Interactive.137/84/DriveMapTB/psf")
  openResults("/home/mseminario2/chips/castalia/simarchive/anatop_tb_controlamp/Interactive.137/84/DriveMapTB/psf")
  when(member('dc results())
    selectResult('dc)
    mtxP = outfile("/home/mseminario2/vestarv/implementations/asic/castalia/analog/data/raw/drive_map__sf84.meta" "w")
    fprintf(mtxP "sweep %%L\n" car(errset(sweepNames())))
    close(mtxP)
    errset(mtxDump("/home/mseminario2/vestarv/implementations/asic/castalia/analog/data/raw/drive_map__sf84__i_sink.csv" cross((v("/V_OutOL")-v("/V_InP")) 0.05 1 "falling")))
    errset(mtxDump("/home/mseminario2/vestarv/implementations/asic/castalia/analog/data/raw/drive_map__sf84__i_span.csv" (cross((v("/V_OutOL")-v("/V_InP")) -0.05 1 "falling")-cross((v("/V_OutOL")-v("/V_InP")) 0.05 1 "falling"))))
    errset(mtxDump("/home/mseminario2/vestarv/implementations/asic/castalia/analog/data/raw/drive_map__sf84__i_src.csv" cross((v("/V_OutOL")-v("/V_InP")) -0.05 1 "falling")))
    errset(mtxDump("/home/mseminario2/vestarv/implementations/asic/castalia/analog/data/raw/drive_map__sf84__idd_q.csv" value(abs(i("/POWER/SRC_VDD25/PLUS")) 0.0)))
    errset(mtxDump("/home/mseminario2/vestarv/implementations/asic/castalia/analog/data/raw/drive_map__sf84__rout.csv" abs((value(v("/V_OutOL") 0.5e-6)-value(v("/V_OutOL") -0.5e-6))/1e-6)))
    errset(mtxDump("/home/mseminario2/vestarv/implementations/asic/castalia/analog/data/raw/drive_map__sf84__verr.csv" (v("/V_OutOL")-v("/V_InP"))))
    errset(mtxDump("/home/mseminario2/vestarv/implementations/asic/castalia/analog/data/raw/drive_map__sf84__verr_q.csv" value((v("/V_OutOL")-v("/V_InP")) 0.0)))
  )
)

;; ---- corner 85 (ss85) / test drive_map
when(isDir("/home/mseminario2/chips/castalia/simarchive/anatop_tb_controlamp/Interactive.137/85/DriveMapTB/psf")
  openResults("/home/mseminario2/chips/castalia/simarchive/anatop_tb_controlamp/Interactive.137/85/DriveMapTB/psf")
  when(member('dc results())
    selectResult('dc)
    mtxP = outfile("/home/mseminario2/vestarv/implementations/asic/castalia/analog/data/raw/drive_map__ss85.meta" "w")
    fprintf(mtxP "sweep %%L\n" car(errset(sweepNames())))
    close(mtxP)
    errset(mtxDump("/home/mseminario2/vestarv/implementations/asic/castalia/analog/data/raw/drive_map__ss85__i_sink.csv" cross((v("/V_OutOL")-v("/V_InP")) 0.05 1 "falling")))
    errset(mtxDump("/home/mseminario2/vestarv/implementations/asic/castalia/analog/data/raw/drive_map__ss85__i_span.csv" (cross((v("/V_OutOL")-v("/V_InP")) -0.05 1 "falling")-cross((v("/V_OutOL")-v("/V_InP")) 0.05 1 "falling"))))
    errset(mtxDump("/home/mseminario2/vestarv/implementations/asic/castalia/analog/data/raw/drive_map__ss85__i_src.csv" cross((v("/V_OutOL")-v("/V_InP")) -0.05 1 "falling")))
    errset(mtxDump("/home/mseminario2/vestarv/implementations/asic/castalia/analog/data/raw/drive_map__ss85__idd_q.csv" value(abs(i("/POWER/SRC_VDD25/PLUS")) 0.0)))
    errset(mtxDump("/home/mseminario2/vestarv/implementations/asic/castalia/analog/data/raw/drive_map__ss85__rout.csv" abs((value(v("/V_OutOL") 0.5e-6)-value(v("/V_OutOL") -0.5e-6))/1e-6)))
    errset(mtxDump("/home/mseminario2/vestarv/implementations/asic/castalia/analog/data/raw/drive_map__ss85__verr.csv" (v("/V_OutOL")-v("/V_InP"))))
    errset(mtxDump("/home/mseminario2/vestarv/implementations/asic/castalia/analog/data/raw/drive_map__ss85__verr_q.csv" value((v("/V_OutOL")-v("/V_InP")) 0.0)))
  )
)

;; ---- corner 86 (tt86) / test drive_map
when(isDir("/home/mseminario2/chips/castalia/simarchive/anatop_tb_controlamp/Interactive.137/86/DriveMapTB/psf")
  openResults("/home/mseminario2/chips/castalia/simarchive/anatop_tb_controlamp/Interactive.137/86/DriveMapTB/psf")
  when(member('dc results())
    selectResult('dc)
    mtxP = outfile("/home/mseminario2/vestarv/implementations/asic/castalia/analog/data/raw/drive_map__tt86.meta" "w")
    fprintf(mtxP "sweep %%L\n" car(errset(sweepNames())))
    close(mtxP)
    errset(mtxDump("/home/mseminario2/vestarv/implementations/asic/castalia/analog/data/raw/drive_map__tt86__i_sink.csv" cross((v("/V_OutOL")-v("/V_InP")) 0.05 1 "falling")))
    errset(mtxDump("/home/mseminario2/vestarv/implementations/asic/castalia/analog/data/raw/drive_map__tt86__i_span.csv" (cross((v("/V_OutOL")-v("/V_InP")) -0.05 1 "falling")-cross((v("/V_OutOL")-v("/V_InP")) 0.05 1 "falling"))))
    errset(mtxDump("/home/mseminario2/vestarv/implementations/asic/castalia/analog/data/raw/drive_map__tt86__i_src.csv" cross((v("/V_OutOL")-v("/V_InP")) -0.05 1 "falling")))
    errset(mtxDump("/home/mseminario2/vestarv/implementations/asic/castalia/analog/data/raw/drive_map__tt86__idd_q.csv" value(abs(i("/POWER/SRC_VDD25/PLUS")) 0.0)))
    errset(mtxDump("/home/mseminario2/vestarv/implementations/asic/castalia/analog/data/raw/drive_map__tt86__rout.csv" abs((value(v("/V_OutOL") 0.5e-6)-value(v("/V_OutOL") -0.5e-6))/1e-6)))
    errset(mtxDump("/home/mseminario2/vestarv/implementations/asic/castalia/analog/data/raw/drive_map__tt86__verr.csv" (v("/V_OutOL")-v("/V_InP"))))
    errset(mtxDump("/home/mseminario2/vestarv/implementations/asic/castalia/analog/data/raw/drive_map__tt86__verr_q.csv" value((v("/V_OutOL")-v("/V_InP")) 0.0)))
  )
)

;; ---- corner 87 (ff87) / test drive_map
when(isDir("/home/mseminario2/chips/castalia/simarchive/anatop_tb_controlamp/Interactive.137/87/DriveMapTB/psf")
  openResults("/home/mseminario2/chips/castalia/simarchive/anatop_tb_controlamp/Interactive.137/87/DriveMapTB/psf")
  when(member('dc results())
    selectResult('dc)
    mtxP = outfile("/home/mseminario2/vestarv/implementations/asic/castalia/analog/data/raw/drive_map__ff87.meta" "w")
    fprintf(mtxP "sweep %%L\n" car(errset(sweepNames())))
    close(mtxP)
    errset(mtxDump("/home/mseminario2/vestarv/implementations/asic/castalia/analog/data/raw/drive_map__ff87__i_sink.csv" cross((v("/V_OutOL")-v("/V_InP")) 0.05 1 "falling")))
    errset(mtxDump("/home/mseminario2/vestarv/implementations/asic/castalia/analog/data/raw/drive_map__ff87__i_span.csv" (cross((v("/V_OutOL")-v("/V_InP")) -0.05 1 "falling")-cross((v("/V_OutOL")-v("/V_InP")) 0.05 1 "falling"))))
    errset(mtxDump("/home/mseminario2/vestarv/implementations/asic/castalia/analog/data/raw/drive_map__ff87__i_src.csv" cross((v("/V_OutOL")-v("/V_InP")) -0.05 1 "falling")))
    errset(mtxDump("/home/mseminario2/vestarv/implementations/asic/castalia/analog/data/raw/drive_map__ff87__idd_q.csv" value(abs(i("/POWER/SRC_VDD25/PLUS")) 0.0)))
    errset(mtxDump("/home/mseminario2/vestarv/implementations/asic/castalia/analog/data/raw/drive_map__ff87__rout.csv" abs((value(v("/V_OutOL") 0.5e-6)-value(v("/V_OutOL") -0.5e-6))/1e-6)))
    errset(mtxDump("/home/mseminario2/vestarv/implementations/asic/castalia/analog/data/raw/drive_map__ff87__verr.csv" (v("/V_OutOL")-v("/V_InP"))))
    errset(mtxDump("/home/mseminario2/vestarv/implementations/asic/castalia/analog/data/raw/drive_map__ff87__verr_q.csv" value((v("/V_OutOL")-v("/V_InP")) 0.0)))
  )
)

;; ---- corner 88 (fs88) / test drive_map
when(isDir("/home/mseminario2/chips/castalia/simarchive/anatop_tb_controlamp/Interactive.137/88/DriveMapTB/psf")
  openResults("/home/mseminario2/chips/castalia/simarchive/anatop_tb_controlamp/Interactive.137/88/DriveMapTB/psf")
  when(member('dc results())
    selectResult('dc)
    mtxP = outfile("/home/mseminario2/vestarv/implementations/asic/castalia/analog/data/raw/drive_map__fs88.meta" "w")
    fprintf(mtxP "sweep %%L\n" car(errset(sweepNames())))
    close(mtxP)
    errset(mtxDump("/home/mseminario2/vestarv/implementations/asic/castalia/analog/data/raw/drive_map__fs88__i_sink.csv" cross((v("/V_OutOL")-v("/V_InP")) 0.05 1 "falling")))
    errset(mtxDump("/home/mseminario2/vestarv/implementations/asic/castalia/analog/data/raw/drive_map__fs88__i_span.csv" (cross((v("/V_OutOL")-v("/V_InP")) -0.05 1 "falling")-cross((v("/V_OutOL")-v("/V_InP")) 0.05 1 "falling"))))
    errset(mtxDump("/home/mseminario2/vestarv/implementations/asic/castalia/analog/data/raw/drive_map__fs88__i_src.csv" cross((v("/V_OutOL")-v("/V_InP")) -0.05 1 "falling")))
    errset(mtxDump("/home/mseminario2/vestarv/implementations/asic/castalia/analog/data/raw/drive_map__fs88__idd_q.csv" value(abs(i("/POWER/SRC_VDD25/PLUS")) 0.0)))
    errset(mtxDump("/home/mseminario2/vestarv/implementations/asic/castalia/analog/data/raw/drive_map__fs88__rout.csv" abs((value(v("/V_OutOL") 0.5e-6)-value(v("/V_OutOL") -0.5e-6))/1e-6)))
    errset(mtxDump("/home/mseminario2/vestarv/implementations/asic/castalia/analog/data/raw/drive_map__fs88__verr.csv" (v("/V_OutOL")-v("/V_InP"))))
    errset(mtxDump("/home/mseminario2/vestarv/implementations/asic/castalia/analog/data/raw/drive_map__fs88__verr_q.csv" value((v("/V_OutOL")-v("/V_InP")) 0.0)))
  )
)

;; ---- corner 89 (sf89) / test drive_map
when(isDir("/home/mseminario2/chips/castalia/simarchive/anatop_tb_controlamp/Interactive.137/89/DriveMapTB/psf")
  openResults("/home/mseminario2/chips/castalia/simarchive/anatop_tb_controlamp/Interactive.137/89/DriveMapTB/psf")
  when(member('dc results())
    selectResult('dc)
    mtxP = outfile("/home/mseminario2/vestarv/implementations/asic/castalia/analog/data/raw/drive_map__sf89.meta" "w")
    fprintf(mtxP "sweep %%L\n" car(errset(sweepNames())))
    close(mtxP)
    errset(mtxDump("/home/mseminario2/vestarv/implementations/asic/castalia/analog/data/raw/drive_map__sf89__i_sink.csv" cross((v("/V_OutOL")-v("/V_InP")) 0.05 1 "falling")))
    errset(mtxDump("/home/mseminario2/vestarv/implementations/asic/castalia/analog/data/raw/drive_map__sf89__i_span.csv" (cross((v("/V_OutOL")-v("/V_InP")) -0.05 1 "falling")-cross((v("/V_OutOL")-v("/V_InP")) 0.05 1 "falling"))))
    errset(mtxDump("/home/mseminario2/vestarv/implementations/asic/castalia/analog/data/raw/drive_map__sf89__i_src.csv" cross((v("/V_OutOL")-v("/V_InP")) -0.05 1 "falling")))
    errset(mtxDump("/home/mseminario2/vestarv/implementations/asic/castalia/analog/data/raw/drive_map__sf89__idd_q.csv" value(abs(i("/POWER/SRC_VDD25/PLUS")) 0.0)))
    errset(mtxDump("/home/mseminario2/vestarv/implementations/asic/castalia/analog/data/raw/drive_map__sf89__rout.csv" abs((value(v("/V_OutOL") 0.5e-6)-value(v("/V_OutOL") -0.5e-6))/1e-6)))
    errset(mtxDump("/home/mseminario2/vestarv/implementations/asic/castalia/analog/data/raw/drive_map__sf89__verr.csv" (v("/V_OutOL")-v("/V_InP"))))
    errset(mtxDump("/home/mseminario2/vestarv/implementations/asic/castalia/analog/data/raw/drive_map__sf89__verr_q.csv" value((v("/V_OutOL")-v("/V_InP")) 0.0)))
  )
)

;; ---- corner 90 (ss90) / test drive_map
when(isDir("/home/mseminario2/chips/castalia/simarchive/anatop_tb_controlamp/Interactive.137/90/DriveMapTB/psf")
  openResults("/home/mseminario2/chips/castalia/simarchive/anatop_tb_controlamp/Interactive.137/90/DriveMapTB/psf")
  when(member('dc results())
    selectResult('dc)
    mtxP = outfile("/home/mseminario2/vestarv/implementations/asic/castalia/analog/data/raw/drive_map__ss90.meta" "w")
    fprintf(mtxP "sweep %%L\n" car(errset(sweepNames())))
    close(mtxP)
    errset(mtxDump("/home/mseminario2/vestarv/implementations/asic/castalia/analog/data/raw/drive_map__ss90__i_sink.csv" cross((v("/V_OutOL")-v("/V_InP")) 0.05 1 "falling")))
    errset(mtxDump("/home/mseminario2/vestarv/implementations/asic/castalia/analog/data/raw/drive_map__ss90__i_span.csv" (cross((v("/V_OutOL")-v("/V_InP")) -0.05 1 "falling")-cross((v("/V_OutOL")-v("/V_InP")) 0.05 1 "falling"))))
    errset(mtxDump("/home/mseminario2/vestarv/implementations/asic/castalia/analog/data/raw/drive_map__ss90__i_src.csv" cross((v("/V_OutOL")-v("/V_InP")) -0.05 1 "falling")))
    errset(mtxDump("/home/mseminario2/vestarv/implementations/asic/castalia/analog/data/raw/drive_map__ss90__idd_q.csv" value(abs(i("/POWER/SRC_VDD25/PLUS")) 0.0)))
    errset(mtxDump("/home/mseminario2/vestarv/implementations/asic/castalia/analog/data/raw/drive_map__ss90__rout.csv" abs((value(v("/V_OutOL") 0.5e-6)-value(v("/V_OutOL") -0.5e-6))/1e-6)))
    errset(mtxDump("/home/mseminario2/vestarv/implementations/asic/castalia/analog/data/raw/drive_map__ss90__verr.csv" (v("/V_OutOL")-v("/V_InP"))))
    errset(mtxDump("/home/mseminario2/vestarv/implementations/asic/castalia/analog/data/raw/drive_map__ss90__verr_q.csv" value((v("/V_OutOL")-v("/V_InP")) 0.0)))
  )
)

;; ---- corner 91 (tt91) / test drive_map
when(isDir("/home/mseminario2/chips/castalia/simarchive/anatop_tb_controlamp/Interactive.137/91/DriveMapTB/psf")
  openResults("/home/mseminario2/chips/castalia/simarchive/anatop_tb_controlamp/Interactive.137/91/DriveMapTB/psf")
  when(member('dc results())
    selectResult('dc)
    mtxP = outfile("/home/mseminario2/vestarv/implementations/asic/castalia/analog/data/raw/drive_map__tt91.meta" "w")
    fprintf(mtxP "sweep %%L\n" car(errset(sweepNames())))
    close(mtxP)
    errset(mtxDump("/home/mseminario2/vestarv/implementations/asic/castalia/analog/data/raw/drive_map__tt91__i_sink.csv" cross((v("/V_OutOL")-v("/V_InP")) 0.05 1 "falling")))
    errset(mtxDump("/home/mseminario2/vestarv/implementations/asic/castalia/analog/data/raw/drive_map__tt91__i_span.csv" (cross((v("/V_OutOL")-v("/V_InP")) -0.05 1 "falling")-cross((v("/V_OutOL")-v("/V_InP")) 0.05 1 "falling"))))
    errset(mtxDump("/home/mseminario2/vestarv/implementations/asic/castalia/analog/data/raw/drive_map__tt91__i_src.csv" cross((v("/V_OutOL")-v("/V_InP")) -0.05 1 "falling")))
    errset(mtxDump("/home/mseminario2/vestarv/implementations/asic/castalia/analog/data/raw/drive_map__tt91__idd_q.csv" value(abs(i("/POWER/SRC_VDD25/PLUS")) 0.0)))
    errset(mtxDump("/home/mseminario2/vestarv/implementations/asic/castalia/analog/data/raw/drive_map__tt91__rout.csv" abs((value(v("/V_OutOL") 0.5e-6)-value(v("/V_OutOL") -0.5e-6))/1e-6)))
    errset(mtxDump("/home/mseminario2/vestarv/implementations/asic/castalia/analog/data/raw/drive_map__tt91__verr.csv" (v("/V_OutOL")-v("/V_InP"))))
    errset(mtxDump("/home/mseminario2/vestarv/implementations/asic/castalia/analog/data/raw/drive_map__tt91__verr_q.csv" value((v("/V_OutOL")-v("/V_InP")) 0.0)))
  )
)

;; ---- corner 92 (ff92) / test drive_map
when(isDir("/home/mseminario2/chips/castalia/simarchive/anatop_tb_controlamp/Interactive.137/92/DriveMapTB/psf")
  openResults("/home/mseminario2/chips/castalia/simarchive/anatop_tb_controlamp/Interactive.137/92/DriveMapTB/psf")
  when(member('dc results())
    selectResult('dc)
    mtxP = outfile("/home/mseminario2/vestarv/implementations/asic/castalia/analog/data/raw/drive_map__ff92.meta" "w")
    fprintf(mtxP "sweep %%L\n" car(errset(sweepNames())))
    close(mtxP)
    errset(mtxDump("/home/mseminario2/vestarv/implementations/asic/castalia/analog/data/raw/drive_map__ff92__i_sink.csv" cross((v("/V_OutOL")-v("/V_InP")) 0.05 1 "falling")))
    errset(mtxDump("/home/mseminario2/vestarv/implementations/asic/castalia/analog/data/raw/drive_map__ff92__i_span.csv" (cross((v("/V_OutOL")-v("/V_InP")) -0.05 1 "falling")-cross((v("/V_OutOL")-v("/V_InP")) 0.05 1 "falling"))))
    errset(mtxDump("/home/mseminario2/vestarv/implementations/asic/castalia/analog/data/raw/drive_map__ff92__i_src.csv" cross((v("/V_OutOL")-v("/V_InP")) -0.05 1 "falling")))
    errset(mtxDump("/home/mseminario2/vestarv/implementations/asic/castalia/analog/data/raw/drive_map__ff92__idd_q.csv" value(abs(i("/POWER/SRC_VDD25/PLUS")) 0.0)))
    errset(mtxDump("/home/mseminario2/vestarv/implementations/asic/castalia/analog/data/raw/drive_map__ff92__rout.csv" abs((value(v("/V_OutOL") 0.5e-6)-value(v("/V_OutOL") -0.5e-6))/1e-6)))
    errset(mtxDump("/home/mseminario2/vestarv/implementations/asic/castalia/analog/data/raw/drive_map__ff92__verr.csv" (v("/V_OutOL")-v("/V_InP"))))
    errset(mtxDump("/home/mseminario2/vestarv/implementations/asic/castalia/analog/data/raw/drive_map__ff92__verr_q.csv" value((v("/V_OutOL")-v("/V_InP")) 0.0)))
  )
)

;; ---- corner 93 (fs93) / test drive_map
when(isDir("/home/mseminario2/chips/castalia/simarchive/anatop_tb_controlamp/Interactive.137/93/DriveMapTB/psf")
  openResults("/home/mseminario2/chips/castalia/simarchive/anatop_tb_controlamp/Interactive.137/93/DriveMapTB/psf")
  when(member('dc results())
    selectResult('dc)
    mtxP = outfile("/home/mseminario2/vestarv/implementations/asic/castalia/analog/data/raw/drive_map__fs93.meta" "w")
    fprintf(mtxP "sweep %%L\n" car(errset(sweepNames())))
    close(mtxP)
    errset(mtxDump("/home/mseminario2/vestarv/implementations/asic/castalia/analog/data/raw/drive_map__fs93__i_sink.csv" cross((v("/V_OutOL")-v("/V_InP")) 0.05 1 "falling")))
    errset(mtxDump("/home/mseminario2/vestarv/implementations/asic/castalia/analog/data/raw/drive_map__fs93__i_span.csv" (cross((v("/V_OutOL")-v("/V_InP")) -0.05 1 "falling")-cross((v("/V_OutOL")-v("/V_InP")) 0.05 1 "falling"))))
    errset(mtxDump("/home/mseminario2/vestarv/implementations/asic/castalia/analog/data/raw/drive_map__fs93__i_src.csv" cross((v("/V_OutOL")-v("/V_InP")) -0.05 1 "falling")))
    errset(mtxDump("/home/mseminario2/vestarv/implementations/asic/castalia/analog/data/raw/drive_map__fs93__idd_q.csv" value(abs(i("/POWER/SRC_VDD25/PLUS")) 0.0)))
    errset(mtxDump("/home/mseminario2/vestarv/implementations/asic/castalia/analog/data/raw/drive_map__fs93__rout.csv" abs((value(v("/V_OutOL") 0.5e-6)-value(v("/V_OutOL") -0.5e-6))/1e-6)))
    errset(mtxDump("/home/mseminario2/vestarv/implementations/asic/castalia/analog/data/raw/drive_map__fs93__verr.csv" (v("/V_OutOL")-v("/V_InP"))))
    errset(mtxDump("/home/mseminario2/vestarv/implementations/asic/castalia/analog/data/raw/drive_map__fs93__verr_q.csv" value((v("/V_OutOL")-v("/V_InP")) 0.0)))
  )
)

;; ---- corner 94 (sf94) / test drive_map
when(isDir("/home/mseminario2/chips/castalia/simarchive/anatop_tb_controlamp/Interactive.137/94/DriveMapTB/psf")
  openResults("/home/mseminario2/chips/castalia/simarchive/anatop_tb_controlamp/Interactive.137/94/DriveMapTB/psf")
  when(member('dc results())
    selectResult('dc)
    mtxP = outfile("/home/mseminario2/vestarv/implementations/asic/castalia/analog/data/raw/drive_map__sf94.meta" "w")
    fprintf(mtxP "sweep %%L\n" car(errset(sweepNames())))
    close(mtxP)
    errset(mtxDump("/home/mseminario2/vestarv/implementations/asic/castalia/analog/data/raw/drive_map__sf94__i_sink.csv" cross((v("/V_OutOL")-v("/V_InP")) 0.05 1 "falling")))
    errset(mtxDump("/home/mseminario2/vestarv/implementations/asic/castalia/analog/data/raw/drive_map__sf94__i_span.csv" (cross((v("/V_OutOL")-v("/V_InP")) -0.05 1 "falling")-cross((v("/V_OutOL")-v("/V_InP")) 0.05 1 "falling"))))
    errset(mtxDump("/home/mseminario2/vestarv/implementations/asic/castalia/analog/data/raw/drive_map__sf94__i_src.csv" cross((v("/V_OutOL")-v("/V_InP")) -0.05 1 "falling")))
    errset(mtxDump("/home/mseminario2/vestarv/implementations/asic/castalia/analog/data/raw/drive_map__sf94__idd_q.csv" value(abs(i("/POWER/SRC_VDD25/PLUS")) 0.0)))
    errset(mtxDump("/home/mseminario2/vestarv/implementations/asic/castalia/analog/data/raw/drive_map__sf94__rout.csv" abs((value(v("/V_OutOL") 0.5e-6)-value(v("/V_OutOL") -0.5e-6))/1e-6)))
    errset(mtxDump("/home/mseminario2/vestarv/implementations/asic/castalia/analog/data/raw/drive_map__sf94__verr.csv" (v("/V_OutOL")-v("/V_InP"))))
    errset(mtxDump("/home/mseminario2/vestarv/implementations/asic/castalia/analog/data/raw/drive_map__sf94__verr_q.csv" value((v("/V_OutOL")-v("/V_InP")) 0.0)))
  )
)

;; ---- corner 95 (ss95) / test drive_map
when(isDir("/home/mseminario2/chips/castalia/simarchive/anatop_tb_controlamp/Interactive.137/95/DriveMapTB/psf")
  openResults("/home/mseminario2/chips/castalia/simarchive/anatop_tb_controlamp/Interactive.137/95/DriveMapTB/psf")
  when(member('dc results())
    selectResult('dc)
    mtxP = outfile("/home/mseminario2/vestarv/implementations/asic/castalia/analog/data/raw/drive_map__ss95.meta" "w")
    fprintf(mtxP "sweep %%L\n" car(errset(sweepNames())))
    close(mtxP)
    errset(mtxDump("/home/mseminario2/vestarv/implementations/asic/castalia/analog/data/raw/drive_map__ss95__i_sink.csv" cross((v("/V_OutOL")-v("/V_InP")) 0.05 1 "falling")))
    errset(mtxDump("/home/mseminario2/vestarv/implementations/asic/castalia/analog/data/raw/drive_map__ss95__i_span.csv" (cross((v("/V_OutOL")-v("/V_InP")) -0.05 1 "falling")-cross((v("/V_OutOL")-v("/V_InP")) 0.05 1 "falling"))))
    errset(mtxDump("/home/mseminario2/vestarv/implementations/asic/castalia/analog/data/raw/drive_map__ss95__i_src.csv" cross((v("/V_OutOL")-v("/V_InP")) -0.05 1 "falling")))
    errset(mtxDump("/home/mseminario2/vestarv/implementations/asic/castalia/analog/data/raw/drive_map__ss95__idd_q.csv" value(abs(i("/POWER/SRC_VDD25/PLUS")) 0.0)))
    errset(mtxDump("/home/mseminario2/vestarv/implementations/asic/castalia/analog/data/raw/drive_map__ss95__rout.csv" abs((value(v("/V_OutOL") 0.5e-6)-value(v("/V_OutOL") -0.5e-6))/1e-6)))
    errset(mtxDump("/home/mseminario2/vestarv/implementations/asic/castalia/analog/data/raw/drive_map__ss95__verr.csv" (v("/V_OutOL")-v("/V_InP"))))
    errset(mtxDump("/home/mseminario2/vestarv/implementations/asic/castalia/analog/data/raw/drive_map__ss95__verr_q.csv" value((v("/V_OutOL")-v("/V_InP")) 0.0)))
  )
)

;; ---- corner 96 (tt96) / test drive_map
when(isDir("/home/mseminario2/chips/castalia/simarchive/anatop_tb_controlamp/Interactive.137/96/DriveMapTB/psf")
  openResults("/home/mseminario2/chips/castalia/simarchive/anatop_tb_controlamp/Interactive.137/96/DriveMapTB/psf")
  when(member('dc results())
    selectResult('dc)
    mtxP = outfile("/home/mseminario2/vestarv/implementations/asic/castalia/analog/data/raw/drive_map__tt96.meta" "w")
    fprintf(mtxP "sweep %%L\n" car(errset(sweepNames())))
    close(mtxP)
    errset(mtxDump("/home/mseminario2/vestarv/implementations/asic/castalia/analog/data/raw/drive_map__tt96__i_sink.csv" cross((v("/V_OutOL")-v("/V_InP")) 0.05 1 "falling")))
    errset(mtxDump("/home/mseminario2/vestarv/implementations/asic/castalia/analog/data/raw/drive_map__tt96__i_span.csv" (cross((v("/V_OutOL")-v("/V_InP")) -0.05 1 "falling")-cross((v("/V_OutOL")-v("/V_InP")) 0.05 1 "falling"))))
    errset(mtxDump("/home/mseminario2/vestarv/implementations/asic/castalia/analog/data/raw/drive_map__tt96__i_src.csv" cross((v("/V_OutOL")-v("/V_InP")) -0.05 1 "falling")))
    errset(mtxDump("/home/mseminario2/vestarv/implementations/asic/castalia/analog/data/raw/drive_map__tt96__idd_q.csv" value(abs(i("/POWER/SRC_VDD25/PLUS")) 0.0)))
    errset(mtxDump("/home/mseminario2/vestarv/implementations/asic/castalia/analog/data/raw/drive_map__tt96__rout.csv" abs((value(v("/V_OutOL") 0.5e-6)-value(v("/V_OutOL") -0.5e-6))/1e-6)))
    errset(mtxDump("/home/mseminario2/vestarv/implementations/asic/castalia/analog/data/raw/drive_map__tt96__verr.csv" (v("/V_OutOL")-v("/V_InP"))))
    errset(mtxDump("/home/mseminario2/vestarv/implementations/asic/castalia/analog/data/raw/drive_map__tt96__verr_q.csv" value((v("/V_OutOL")-v("/V_InP")) 0.0)))
  )
)

;; ---- corner 97 (ff97) / test drive_map
when(isDir("/home/mseminario2/chips/castalia/simarchive/anatop_tb_controlamp/Interactive.137/97/DriveMapTB/psf")
  openResults("/home/mseminario2/chips/castalia/simarchive/anatop_tb_controlamp/Interactive.137/97/DriveMapTB/psf")
  when(member('dc results())
    selectResult('dc)
    mtxP = outfile("/home/mseminario2/vestarv/implementations/asic/castalia/analog/data/raw/drive_map__ff97.meta" "w")
    fprintf(mtxP "sweep %%L\n" car(errset(sweepNames())))
    close(mtxP)
    errset(mtxDump("/home/mseminario2/vestarv/implementations/asic/castalia/analog/data/raw/drive_map__ff97__i_sink.csv" cross((v("/V_OutOL")-v("/V_InP")) 0.05 1 "falling")))
    errset(mtxDump("/home/mseminario2/vestarv/implementations/asic/castalia/analog/data/raw/drive_map__ff97__i_span.csv" (cross((v("/V_OutOL")-v("/V_InP")) -0.05 1 "falling")-cross((v("/V_OutOL")-v("/V_InP")) 0.05 1 "falling"))))
    errset(mtxDump("/home/mseminario2/vestarv/implementations/asic/castalia/analog/data/raw/drive_map__ff97__i_src.csv" cross((v("/V_OutOL")-v("/V_InP")) -0.05 1 "falling")))
    errset(mtxDump("/home/mseminario2/vestarv/implementations/asic/castalia/analog/data/raw/drive_map__ff97__idd_q.csv" value(abs(i("/POWER/SRC_VDD25/PLUS")) 0.0)))
    errset(mtxDump("/home/mseminario2/vestarv/implementations/asic/castalia/analog/data/raw/drive_map__ff97__rout.csv" abs((value(v("/V_OutOL") 0.5e-6)-value(v("/V_OutOL") -0.5e-6))/1e-6)))
    errset(mtxDump("/home/mseminario2/vestarv/implementations/asic/castalia/analog/data/raw/drive_map__ff97__verr.csv" (v("/V_OutOL")-v("/V_InP"))))
    errset(mtxDump("/home/mseminario2/vestarv/implementations/asic/castalia/analog/data/raw/drive_map__ff97__verr_q.csv" value((v("/V_OutOL")-v("/V_InP")) 0.0)))
  )
)

;; ---- corner 98 (fs98) / test drive_map
when(isDir("/home/mseminario2/chips/castalia/simarchive/anatop_tb_controlamp/Interactive.137/98/DriveMapTB/psf")
  openResults("/home/mseminario2/chips/castalia/simarchive/anatop_tb_controlamp/Interactive.137/98/DriveMapTB/psf")
  when(member('dc results())
    selectResult('dc)
    mtxP = outfile("/home/mseminario2/vestarv/implementations/asic/castalia/analog/data/raw/drive_map__fs98.meta" "w")
    fprintf(mtxP "sweep %%L\n" car(errset(sweepNames())))
    close(mtxP)
    errset(mtxDump("/home/mseminario2/vestarv/implementations/asic/castalia/analog/data/raw/drive_map__fs98__i_sink.csv" cross((v("/V_OutOL")-v("/V_InP")) 0.05 1 "falling")))
    errset(mtxDump("/home/mseminario2/vestarv/implementations/asic/castalia/analog/data/raw/drive_map__fs98__i_span.csv" (cross((v("/V_OutOL")-v("/V_InP")) -0.05 1 "falling")-cross((v("/V_OutOL")-v("/V_InP")) 0.05 1 "falling"))))
    errset(mtxDump("/home/mseminario2/vestarv/implementations/asic/castalia/analog/data/raw/drive_map__fs98__i_src.csv" cross((v("/V_OutOL")-v("/V_InP")) -0.05 1 "falling")))
    errset(mtxDump("/home/mseminario2/vestarv/implementations/asic/castalia/analog/data/raw/drive_map__fs98__idd_q.csv" value(abs(i("/POWER/SRC_VDD25/PLUS")) 0.0)))
    errset(mtxDump("/home/mseminario2/vestarv/implementations/asic/castalia/analog/data/raw/drive_map__fs98__rout.csv" abs((value(v("/V_OutOL") 0.5e-6)-value(v("/V_OutOL") -0.5e-6))/1e-6)))
    errset(mtxDump("/home/mseminario2/vestarv/implementations/asic/castalia/analog/data/raw/drive_map__fs98__verr.csv" (v("/V_OutOL")-v("/V_InP"))))
    errset(mtxDump("/home/mseminario2/vestarv/implementations/asic/castalia/analog/data/raw/drive_map__fs98__verr_q.csv" value((v("/V_OutOL")-v("/V_InP")) 0.0)))
  )
)

;; ---- corner 99 (sf99) / test drive_map
when(isDir("/home/mseminario2/chips/castalia/simarchive/anatop_tb_controlamp/Interactive.137/99/DriveMapTB/psf")
  openResults("/home/mseminario2/chips/castalia/simarchive/anatop_tb_controlamp/Interactive.137/99/DriveMapTB/psf")
  when(member('dc results())
    selectResult('dc)
    mtxP = outfile("/home/mseminario2/vestarv/implementations/asic/castalia/analog/data/raw/drive_map__sf99.meta" "w")
    fprintf(mtxP "sweep %%L\n" car(errset(sweepNames())))
    close(mtxP)
    errset(mtxDump("/home/mseminario2/vestarv/implementations/asic/castalia/analog/data/raw/drive_map__sf99__i_sink.csv" cross((v("/V_OutOL")-v("/V_InP")) 0.05 1 "falling")))
    errset(mtxDump("/home/mseminario2/vestarv/implementations/asic/castalia/analog/data/raw/drive_map__sf99__i_span.csv" (cross((v("/V_OutOL")-v("/V_InP")) -0.05 1 "falling")-cross((v("/V_OutOL")-v("/V_InP")) 0.05 1 "falling"))))
    errset(mtxDump("/home/mseminario2/vestarv/implementations/asic/castalia/analog/data/raw/drive_map__sf99__i_src.csv" cross((v("/V_OutOL")-v("/V_InP")) -0.05 1 "falling")))
    errset(mtxDump("/home/mseminario2/vestarv/implementations/asic/castalia/analog/data/raw/drive_map__sf99__idd_q.csv" value(abs(i("/POWER/SRC_VDD25/PLUS")) 0.0)))
    errset(mtxDump("/home/mseminario2/vestarv/implementations/asic/castalia/analog/data/raw/drive_map__sf99__rout.csv" abs((value(v("/V_OutOL") 0.5e-6)-value(v("/V_OutOL") -0.5e-6))/1e-6)))
    errset(mtxDump("/home/mseminario2/vestarv/implementations/asic/castalia/analog/data/raw/drive_map__sf99__verr.csv" (v("/V_OutOL")-v("/V_InP"))))
    errset(mtxDump("/home/mseminario2/vestarv/implementations/asic/castalia/analog/data/raw/drive_map__sf99__verr_q.csv" value((v("/V_OutOL")-v("/V_InP")) 0.0)))
  )
)

;; ---- corner 100 (ss100) / test drive_map
when(isDir("/home/mseminario2/chips/castalia/simarchive/anatop_tb_controlamp/Interactive.137/100/DriveMapTB/psf")
  openResults("/home/mseminario2/chips/castalia/simarchive/anatop_tb_controlamp/Interactive.137/100/DriveMapTB/psf")
  when(member('dc results())
    selectResult('dc)
    mtxP = outfile("/home/mseminario2/vestarv/implementations/asic/castalia/analog/data/raw/drive_map__ss100.meta" "w")
    fprintf(mtxP "sweep %%L\n" car(errset(sweepNames())))
    close(mtxP)
    errset(mtxDump("/home/mseminario2/vestarv/implementations/asic/castalia/analog/data/raw/drive_map__ss100__i_sink.csv" cross((v("/V_OutOL")-v("/V_InP")) 0.05 1 "falling")))
    errset(mtxDump("/home/mseminario2/vestarv/implementations/asic/castalia/analog/data/raw/drive_map__ss100__i_span.csv" (cross((v("/V_OutOL")-v("/V_InP")) -0.05 1 "falling")-cross((v("/V_OutOL")-v("/V_InP")) 0.05 1 "falling"))))
    errset(mtxDump("/home/mseminario2/vestarv/implementations/asic/castalia/analog/data/raw/drive_map__ss100__i_src.csv" cross((v("/V_OutOL")-v("/V_InP")) -0.05 1 "falling")))
    errset(mtxDump("/home/mseminario2/vestarv/implementations/asic/castalia/analog/data/raw/drive_map__ss100__idd_q.csv" value(abs(i("/POWER/SRC_VDD25/PLUS")) 0.0)))
    errset(mtxDump("/home/mseminario2/vestarv/implementations/asic/castalia/analog/data/raw/drive_map__ss100__rout.csv" abs((value(v("/V_OutOL") 0.5e-6)-value(v("/V_OutOL") -0.5e-6))/1e-6)))
    errset(mtxDump("/home/mseminario2/vestarv/implementations/asic/castalia/analog/data/raw/drive_map__ss100__verr.csv" (v("/V_OutOL")-v("/V_InP"))))
    errset(mtxDump("/home/mseminario2/vestarv/implementations/asic/castalia/analog/data/raw/drive_map__ss100__verr_q.csv" value((v("/V_OutOL")-v("/V_InP")) 0.0)))
  )
)

;; ---- corner 101 (tt101) / test drive_map
when(isDir("/home/mseminario2/chips/castalia/simarchive/anatop_tb_controlamp/Interactive.137/101/DriveMapTB/psf")
  openResults("/home/mseminario2/chips/castalia/simarchive/anatop_tb_controlamp/Interactive.137/101/DriveMapTB/psf")
  when(member('dc results())
    selectResult('dc)
    mtxP = outfile("/home/mseminario2/vestarv/implementations/asic/castalia/analog/data/raw/drive_map__tt101.meta" "w")
    fprintf(mtxP "sweep %%L\n" car(errset(sweepNames())))
    close(mtxP)
    errset(mtxDump("/home/mseminario2/vestarv/implementations/asic/castalia/analog/data/raw/drive_map__tt101__i_sink.csv" cross((v("/V_OutOL")-v("/V_InP")) 0.05 1 "falling")))
    errset(mtxDump("/home/mseminario2/vestarv/implementations/asic/castalia/analog/data/raw/drive_map__tt101__i_span.csv" (cross((v("/V_OutOL")-v("/V_InP")) -0.05 1 "falling")-cross((v("/V_OutOL")-v("/V_InP")) 0.05 1 "falling"))))
    errset(mtxDump("/home/mseminario2/vestarv/implementations/asic/castalia/analog/data/raw/drive_map__tt101__i_src.csv" cross((v("/V_OutOL")-v("/V_InP")) -0.05 1 "falling")))
    errset(mtxDump("/home/mseminario2/vestarv/implementations/asic/castalia/analog/data/raw/drive_map__tt101__idd_q.csv" value(abs(i("/POWER/SRC_VDD25/PLUS")) 0.0)))
    errset(mtxDump("/home/mseminario2/vestarv/implementations/asic/castalia/analog/data/raw/drive_map__tt101__rout.csv" abs((value(v("/V_OutOL") 0.5e-6)-value(v("/V_OutOL") -0.5e-6))/1e-6)))
    errset(mtxDump("/home/mseminario2/vestarv/implementations/asic/castalia/analog/data/raw/drive_map__tt101__verr.csv" (v("/V_OutOL")-v("/V_InP"))))
    errset(mtxDump("/home/mseminario2/vestarv/implementations/asic/castalia/analog/data/raw/drive_map__tt101__verr_q.csv" value((v("/V_OutOL")-v("/V_InP")) 0.0)))
  )
)

;; ---- corner 102 (ff102) / test drive_map
when(isDir("/home/mseminario2/chips/castalia/simarchive/anatop_tb_controlamp/Interactive.137/102/DriveMapTB/psf")
  openResults("/home/mseminario2/chips/castalia/simarchive/anatop_tb_controlamp/Interactive.137/102/DriveMapTB/psf")
  when(member('dc results())
    selectResult('dc)
    mtxP = outfile("/home/mseminario2/vestarv/implementations/asic/castalia/analog/data/raw/drive_map__ff102.meta" "w")
    fprintf(mtxP "sweep %%L\n" car(errset(sweepNames())))
    close(mtxP)
    errset(mtxDump("/home/mseminario2/vestarv/implementations/asic/castalia/analog/data/raw/drive_map__ff102__i_sink.csv" cross((v("/V_OutOL")-v("/V_InP")) 0.05 1 "falling")))
    errset(mtxDump("/home/mseminario2/vestarv/implementations/asic/castalia/analog/data/raw/drive_map__ff102__i_span.csv" (cross((v("/V_OutOL")-v("/V_InP")) -0.05 1 "falling")-cross((v("/V_OutOL")-v("/V_InP")) 0.05 1 "falling"))))
    errset(mtxDump("/home/mseminario2/vestarv/implementations/asic/castalia/analog/data/raw/drive_map__ff102__i_src.csv" cross((v("/V_OutOL")-v("/V_InP")) -0.05 1 "falling")))
    errset(mtxDump("/home/mseminario2/vestarv/implementations/asic/castalia/analog/data/raw/drive_map__ff102__idd_q.csv" value(abs(i("/POWER/SRC_VDD25/PLUS")) 0.0)))
    errset(mtxDump("/home/mseminario2/vestarv/implementations/asic/castalia/analog/data/raw/drive_map__ff102__rout.csv" abs((value(v("/V_OutOL") 0.5e-6)-value(v("/V_OutOL") -0.5e-6))/1e-6)))
    errset(mtxDump("/home/mseminario2/vestarv/implementations/asic/castalia/analog/data/raw/drive_map__ff102__verr.csv" (v("/V_OutOL")-v("/V_InP"))))
    errset(mtxDump("/home/mseminario2/vestarv/implementations/asic/castalia/analog/data/raw/drive_map__ff102__verr_q.csv" value((v("/V_OutOL")-v("/V_InP")) 0.0)))
  )
)

;; ---- corner 103 (fs103) / test drive_map
when(isDir("/home/mseminario2/chips/castalia/simarchive/anatop_tb_controlamp/Interactive.137/103/DriveMapTB/psf")
  openResults("/home/mseminario2/chips/castalia/simarchive/anatop_tb_controlamp/Interactive.137/103/DriveMapTB/psf")
  when(member('dc results())
    selectResult('dc)
    mtxP = outfile("/home/mseminario2/vestarv/implementations/asic/castalia/analog/data/raw/drive_map__fs103.meta" "w")
    fprintf(mtxP "sweep %%L\n" car(errset(sweepNames())))
    close(mtxP)
    errset(mtxDump("/home/mseminario2/vestarv/implementations/asic/castalia/analog/data/raw/drive_map__fs103__i_sink.csv" cross((v("/V_OutOL")-v("/V_InP")) 0.05 1 "falling")))
    errset(mtxDump("/home/mseminario2/vestarv/implementations/asic/castalia/analog/data/raw/drive_map__fs103__i_span.csv" (cross((v("/V_OutOL")-v("/V_InP")) -0.05 1 "falling")-cross((v("/V_OutOL")-v("/V_InP")) 0.05 1 "falling"))))
    errset(mtxDump("/home/mseminario2/vestarv/implementations/asic/castalia/analog/data/raw/drive_map__fs103__i_src.csv" cross((v("/V_OutOL")-v("/V_InP")) -0.05 1 "falling")))
    errset(mtxDump("/home/mseminario2/vestarv/implementations/asic/castalia/analog/data/raw/drive_map__fs103__idd_q.csv" value(abs(i("/POWER/SRC_VDD25/PLUS")) 0.0)))
    errset(mtxDump("/home/mseminario2/vestarv/implementations/asic/castalia/analog/data/raw/drive_map__fs103__rout.csv" abs((value(v("/V_OutOL") 0.5e-6)-value(v("/V_OutOL") -0.5e-6))/1e-6)))
    errset(mtxDump("/home/mseminario2/vestarv/implementations/asic/castalia/analog/data/raw/drive_map__fs103__verr.csv" (v("/V_OutOL")-v("/V_InP"))))
    errset(mtxDump("/home/mseminario2/vestarv/implementations/asic/castalia/analog/data/raw/drive_map__fs103__verr_q.csv" value((v("/V_OutOL")-v("/V_InP")) 0.0)))
  )
)

;; ---- corner 104 (sf104) / test drive_map
when(isDir("/home/mseminario2/chips/castalia/simarchive/anatop_tb_controlamp/Interactive.137/104/DriveMapTB/psf")
  openResults("/home/mseminario2/chips/castalia/simarchive/anatop_tb_controlamp/Interactive.137/104/DriveMapTB/psf")
  when(member('dc results())
    selectResult('dc)
    mtxP = outfile("/home/mseminario2/vestarv/implementations/asic/castalia/analog/data/raw/drive_map__sf104.meta" "w")
    fprintf(mtxP "sweep %%L\n" car(errset(sweepNames())))
    close(mtxP)
    errset(mtxDump("/home/mseminario2/vestarv/implementations/asic/castalia/analog/data/raw/drive_map__sf104__i_sink.csv" cross((v("/V_OutOL")-v("/V_InP")) 0.05 1 "falling")))
    errset(mtxDump("/home/mseminario2/vestarv/implementations/asic/castalia/analog/data/raw/drive_map__sf104__i_span.csv" (cross((v("/V_OutOL")-v("/V_InP")) -0.05 1 "falling")-cross((v("/V_OutOL")-v("/V_InP")) 0.05 1 "falling"))))
    errset(mtxDump("/home/mseminario2/vestarv/implementations/asic/castalia/analog/data/raw/drive_map__sf104__i_src.csv" cross((v("/V_OutOL")-v("/V_InP")) -0.05 1 "falling")))
    errset(mtxDump("/home/mseminario2/vestarv/implementations/asic/castalia/analog/data/raw/drive_map__sf104__idd_q.csv" value(abs(i("/POWER/SRC_VDD25/PLUS")) 0.0)))
    errset(mtxDump("/home/mseminario2/vestarv/implementations/asic/castalia/analog/data/raw/drive_map__sf104__rout.csv" abs((value(v("/V_OutOL") 0.5e-6)-value(v("/V_OutOL") -0.5e-6))/1e-6)))
    errset(mtxDump("/home/mseminario2/vestarv/implementations/asic/castalia/analog/data/raw/drive_map__sf104__verr.csv" (v("/V_OutOL")-v("/V_InP"))))
    errset(mtxDump("/home/mseminario2/vestarv/implementations/asic/castalia/analog/data/raw/drive_map__sf104__verr_q.csv" value((v("/V_OutOL")-v("/V_InP")) 0.0)))
  )
)

;; ---- corner 105 (ss105) / test drive_map
when(isDir("/home/mseminario2/chips/castalia/simarchive/anatop_tb_controlamp/Interactive.137/105/DriveMapTB/psf")
  openResults("/home/mseminario2/chips/castalia/simarchive/anatop_tb_controlamp/Interactive.137/105/DriveMapTB/psf")
  when(member('dc results())
    selectResult('dc)
    mtxP = outfile("/home/mseminario2/vestarv/implementations/asic/castalia/analog/data/raw/drive_map__ss105.meta" "w")
    fprintf(mtxP "sweep %%L\n" car(errset(sweepNames())))
    close(mtxP)
    errset(mtxDump("/home/mseminario2/vestarv/implementations/asic/castalia/analog/data/raw/drive_map__ss105__i_sink.csv" cross((v("/V_OutOL")-v("/V_InP")) 0.05 1 "falling")))
    errset(mtxDump("/home/mseminario2/vestarv/implementations/asic/castalia/analog/data/raw/drive_map__ss105__i_span.csv" (cross((v("/V_OutOL")-v("/V_InP")) -0.05 1 "falling")-cross((v("/V_OutOL")-v("/V_InP")) 0.05 1 "falling"))))
    errset(mtxDump("/home/mseminario2/vestarv/implementations/asic/castalia/analog/data/raw/drive_map__ss105__i_src.csv" cross((v("/V_OutOL")-v("/V_InP")) -0.05 1 "falling")))
    errset(mtxDump("/home/mseminario2/vestarv/implementations/asic/castalia/analog/data/raw/drive_map__ss105__idd_q.csv" value(abs(i("/POWER/SRC_VDD25/PLUS")) 0.0)))
    errset(mtxDump("/home/mseminario2/vestarv/implementations/asic/castalia/analog/data/raw/drive_map__ss105__rout.csv" abs((value(v("/V_OutOL") 0.5e-6)-value(v("/V_OutOL") -0.5e-6))/1e-6)))
    errset(mtxDump("/home/mseminario2/vestarv/implementations/asic/castalia/analog/data/raw/drive_map__ss105__verr.csv" (v("/V_OutOL")-v("/V_InP"))))
    errset(mtxDump("/home/mseminario2/vestarv/implementations/asic/castalia/analog/data/raw/drive_map__ss105__verr_q.csv" value((v("/V_OutOL")-v("/V_InP")) 0.0)))
  )
)

;; ---- corner 106 (tt106) / test drive_map
when(isDir("/home/mseminario2/chips/castalia/simarchive/anatop_tb_controlamp/Interactive.137/106/DriveMapTB/psf")
  openResults("/home/mseminario2/chips/castalia/simarchive/anatop_tb_controlamp/Interactive.137/106/DriveMapTB/psf")
  when(member('dc results())
    selectResult('dc)
    mtxP = outfile("/home/mseminario2/vestarv/implementations/asic/castalia/analog/data/raw/drive_map__tt106.meta" "w")
    fprintf(mtxP "sweep %%L\n" car(errset(sweepNames())))
    close(mtxP)
    errset(mtxDump("/home/mseminario2/vestarv/implementations/asic/castalia/analog/data/raw/drive_map__tt106__i_sink.csv" cross((v("/V_OutOL")-v("/V_InP")) 0.05 1 "falling")))
    errset(mtxDump("/home/mseminario2/vestarv/implementations/asic/castalia/analog/data/raw/drive_map__tt106__i_span.csv" (cross((v("/V_OutOL")-v("/V_InP")) -0.05 1 "falling")-cross((v("/V_OutOL")-v("/V_InP")) 0.05 1 "falling"))))
    errset(mtxDump("/home/mseminario2/vestarv/implementations/asic/castalia/analog/data/raw/drive_map__tt106__i_src.csv" cross((v("/V_OutOL")-v("/V_InP")) -0.05 1 "falling")))
    errset(mtxDump("/home/mseminario2/vestarv/implementations/asic/castalia/analog/data/raw/drive_map__tt106__idd_q.csv" value(abs(i("/POWER/SRC_VDD25/PLUS")) 0.0)))
    errset(mtxDump("/home/mseminario2/vestarv/implementations/asic/castalia/analog/data/raw/drive_map__tt106__rout.csv" abs((value(v("/V_OutOL") 0.5e-6)-value(v("/V_OutOL") -0.5e-6))/1e-6)))
    errset(mtxDump("/home/mseminario2/vestarv/implementations/asic/castalia/analog/data/raw/drive_map__tt106__verr.csv" (v("/V_OutOL")-v("/V_InP"))))
    errset(mtxDump("/home/mseminario2/vestarv/implementations/asic/castalia/analog/data/raw/drive_map__tt106__verr_q.csv" value((v("/V_OutOL")-v("/V_InP")) 0.0)))
  )
)

;; ---- corner 107 (ff107) / test drive_map
when(isDir("/home/mseminario2/chips/castalia/simarchive/anatop_tb_controlamp/Interactive.137/107/DriveMapTB/psf")
  openResults("/home/mseminario2/chips/castalia/simarchive/anatop_tb_controlamp/Interactive.137/107/DriveMapTB/psf")
  when(member('dc results())
    selectResult('dc)
    mtxP = outfile("/home/mseminario2/vestarv/implementations/asic/castalia/analog/data/raw/drive_map__ff107.meta" "w")
    fprintf(mtxP "sweep %%L\n" car(errset(sweepNames())))
    close(mtxP)
    errset(mtxDump("/home/mseminario2/vestarv/implementations/asic/castalia/analog/data/raw/drive_map__ff107__i_sink.csv" cross((v("/V_OutOL")-v("/V_InP")) 0.05 1 "falling")))
    errset(mtxDump("/home/mseminario2/vestarv/implementations/asic/castalia/analog/data/raw/drive_map__ff107__i_span.csv" (cross((v("/V_OutOL")-v("/V_InP")) -0.05 1 "falling")-cross((v("/V_OutOL")-v("/V_InP")) 0.05 1 "falling"))))
    errset(mtxDump("/home/mseminario2/vestarv/implementations/asic/castalia/analog/data/raw/drive_map__ff107__i_src.csv" cross((v("/V_OutOL")-v("/V_InP")) -0.05 1 "falling")))
    errset(mtxDump("/home/mseminario2/vestarv/implementations/asic/castalia/analog/data/raw/drive_map__ff107__idd_q.csv" value(abs(i("/POWER/SRC_VDD25/PLUS")) 0.0)))
    errset(mtxDump("/home/mseminario2/vestarv/implementations/asic/castalia/analog/data/raw/drive_map__ff107__rout.csv" abs((value(v("/V_OutOL") 0.5e-6)-value(v("/V_OutOL") -0.5e-6))/1e-6)))
    errset(mtxDump("/home/mseminario2/vestarv/implementations/asic/castalia/analog/data/raw/drive_map__ff107__verr.csv" (v("/V_OutOL")-v("/V_InP"))))
    errset(mtxDump("/home/mseminario2/vestarv/implementations/asic/castalia/analog/data/raw/drive_map__ff107__verr_q.csv" value((v("/V_OutOL")-v("/V_InP")) 0.0)))
  )
)

;; ---- corner 108 (fs108) / test drive_map
when(isDir("/home/mseminario2/chips/castalia/simarchive/anatop_tb_controlamp/Interactive.137/108/DriveMapTB/psf")
  openResults("/home/mseminario2/chips/castalia/simarchive/anatop_tb_controlamp/Interactive.137/108/DriveMapTB/psf")
  when(member('dc results())
    selectResult('dc)
    mtxP = outfile("/home/mseminario2/vestarv/implementations/asic/castalia/analog/data/raw/drive_map__fs108.meta" "w")
    fprintf(mtxP "sweep %%L\n" car(errset(sweepNames())))
    close(mtxP)
    errset(mtxDump("/home/mseminario2/vestarv/implementations/asic/castalia/analog/data/raw/drive_map__fs108__i_sink.csv" cross((v("/V_OutOL")-v("/V_InP")) 0.05 1 "falling")))
    errset(mtxDump("/home/mseminario2/vestarv/implementations/asic/castalia/analog/data/raw/drive_map__fs108__i_span.csv" (cross((v("/V_OutOL")-v("/V_InP")) -0.05 1 "falling")-cross((v("/V_OutOL")-v("/V_InP")) 0.05 1 "falling"))))
    errset(mtxDump("/home/mseminario2/vestarv/implementations/asic/castalia/analog/data/raw/drive_map__fs108__i_src.csv" cross((v("/V_OutOL")-v("/V_InP")) -0.05 1 "falling")))
    errset(mtxDump("/home/mseminario2/vestarv/implementations/asic/castalia/analog/data/raw/drive_map__fs108__idd_q.csv" value(abs(i("/POWER/SRC_VDD25/PLUS")) 0.0)))
    errset(mtxDump("/home/mseminario2/vestarv/implementations/asic/castalia/analog/data/raw/drive_map__fs108__rout.csv" abs((value(v("/V_OutOL") 0.5e-6)-value(v("/V_OutOL") -0.5e-6))/1e-6)))
    errset(mtxDump("/home/mseminario2/vestarv/implementations/asic/castalia/analog/data/raw/drive_map__fs108__verr.csv" (v("/V_OutOL")-v("/V_InP"))))
    errset(mtxDump("/home/mseminario2/vestarv/implementations/asic/castalia/analog/data/raw/drive_map__fs108__verr_q.csv" value((v("/V_OutOL")-v("/V_InP")) 0.0)))
  )
)

;; ---- corner 109 (sf109) / test drive_map
when(isDir("/home/mseminario2/chips/castalia/simarchive/anatop_tb_controlamp/Interactive.137/109/DriveMapTB/psf")
  openResults("/home/mseminario2/chips/castalia/simarchive/anatop_tb_controlamp/Interactive.137/109/DriveMapTB/psf")
  when(member('dc results())
    selectResult('dc)
    mtxP = outfile("/home/mseminario2/vestarv/implementations/asic/castalia/analog/data/raw/drive_map__sf109.meta" "w")
    fprintf(mtxP "sweep %%L\n" car(errset(sweepNames())))
    close(mtxP)
    errset(mtxDump("/home/mseminario2/vestarv/implementations/asic/castalia/analog/data/raw/drive_map__sf109__i_sink.csv" cross((v("/V_OutOL")-v("/V_InP")) 0.05 1 "falling")))
    errset(mtxDump("/home/mseminario2/vestarv/implementations/asic/castalia/analog/data/raw/drive_map__sf109__i_span.csv" (cross((v("/V_OutOL")-v("/V_InP")) -0.05 1 "falling")-cross((v("/V_OutOL")-v("/V_InP")) 0.05 1 "falling"))))
    errset(mtxDump("/home/mseminario2/vestarv/implementations/asic/castalia/analog/data/raw/drive_map__sf109__i_src.csv" cross((v("/V_OutOL")-v("/V_InP")) -0.05 1 "falling")))
    errset(mtxDump("/home/mseminario2/vestarv/implementations/asic/castalia/analog/data/raw/drive_map__sf109__idd_q.csv" value(abs(i("/POWER/SRC_VDD25/PLUS")) 0.0)))
    errset(mtxDump("/home/mseminario2/vestarv/implementations/asic/castalia/analog/data/raw/drive_map__sf109__rout.csv" abs((value(v("/V_OutOL") 0.5e-6)-value(v("/V_OutOL") -0.5e-6))/1e-6)))
    errset(mtxDump("/home/mseminario2/vestarv/implementations/asic/castalia/analog/data/raw/drive_map__sf109__verr.csv" (v("/V_OutOL")-v("/V_InP"))))
    errset(mtxDump("/home/mseminario2/vestarv/implementations/asic/castalia/analog/data/raw/drive_map__sf109__verr_q.csv" value((v("/V_OutOL")-v("/V_InP")) 0.0)))
  )
)

;; ---- corner 110 (ss110) / test drive_map
when(isDir("/home/mseminario2/chips/castalia/simarchive/anatop_tb_controlamp/Interactive.137/110/DriveMapTB/psf")
  openResults("/home/mseminario2/chips/castalia/simarchive/anatop_tb_controlamp/Interactive.137/110/DriveMapTB/psf")
  when(member('dc results())
    selectResult('dc)
    mtxP = outfile("/home/mseminario2/vestarv/implementations/asic/castalia/analog/data/raw/drive_map__ss110.meta" "w")
    fprintf(mtxP "sweep %%L\n" car(errset(sweepNames())))
    close(mtxP)
    errset(mtxDump("/home/mseminario2/vestarv/implementations/asic/castalia/analog/data/raw/drive_map__ss110__i_sink.csv" cross((v("/V_OutOL")-v("/V_InP")) 0.05 1 "falling")))
    errset(mtxDump("/home/mseminario2/vestarv/implementations/asic/castalia/analog/data/raw/drive_map__ss110__i_span.csv" (cross((v("/V_OutOL")-v("/V_InP")) -0.05 1 "falling")-cross((v("/V_OutOL")-v("/V_InP")) 0.05 1 "falling"))))
    errset(mtxDump("/home/mseminario2/vestarv/implementations/asic/castalia/analog/data/raw/drive_map__ss110__i_src.csv" cross((v("/V_OutOL")-v("/V_InP")) -0.05 1 "falling")))
    errset(mtxDump("/home/mseminario2/vestarv/implementations/asic/castalia/analog/data/raw/drive_map__ss110__idd_q.csv" value(abs(i("/POWER/SRC_VDD25/PLUS")) 0.0)))
    errset(mtxDump("/home/mseminario2/vestarv/implementations/asic/castalia/analog/data/raw/drive_map__ss110__rout.csv" abs((value(v("/V_OutOL") 0.5e-6)-value(v("/V_OutOL") -0.5e-6))/1e-6)))
    errset(mtxDump("/home/mseminario2/vestarv/implementations/asic/castalia/analog/data/raw/drive_map__ss110__verr.csv" (v("/V_OutOL")-v("/V_InP"))))
    errset(mtxDump("/home/mseminario2/vestarv/implementations/asic/castalia/analog/data/raw/drive_map__ss110__verr_q.csv" value((v("/V_OutOL")-v("/V_InP")) 0.0)))
  )
)

;; ---- corner 111 (tt111) / test drive_map
when(isDir("/home/mseminario2/chips/castalia/simarchive/anatop_tb_controlamp/Interactive.137/111/DriveMapTB/psf")
  openResults("/home/mseminario2/chips/castalia/simarchive/anatop_tb_controlamp/Interactive.137/111/DriveMapTB/psf")
  when(member('dc results())
    selectResult('dc)
    mtxP = outfile("/home/mseminario2/vestarv/implementations/asic/castalia/analog/data/raw/drive_map__tt111.meta" "w")
    fprintf(mtxP "sweep %%L\n" car(errset(sweepNames())))
    close(mtxP)
    errset(mtxDump("/home/mseminario2/vestarv/implementations/asic/castalia/analog/data/raw/drive_map__tt111__i_sink.csv" cross((v("/V_OutOL")-v("/V_InP")) 0.05 1 "falling")))
    errset(mtxDump("/home/mseminario2/vestarv/implementations/asic/castalia/analog/data/raw/drive_map__tt111__i_span.csv" (cross((v("/V_OutOL")-v("/V_InP")) -0.05 1 "falling")-cross((v("/V_OutOL")-v("/V_InP")) 0.05 1 "falling"))))
    errset(mtxDump("/home/mseminario2/vestarv/implementations/asic/castalia/analog/data/raw/drive_map__tt111__i_src.csv" cross((v("/V_OutOL")-v("/V_InP")) -0.05 1 "falling")))
    errset(mtxDump("/home/mseminario2/vestarv/implementations/asic/castalia/analog/data/raw/drive_map__tt111__idd_q.csv" value(abs(i("/POWER/SRC_VDD25/PLUS")) 0.0)))
    errset(mtxDump("/home/mseminario2/vestarv/implementations/asic/castalia/analog/data/raw/drive_map__tt111__rout.csv" abs((value(v("/V_OutOL") 0.5e-6)-value(v("/V_OutOL") -0.5e-6))/1e-6)))
    errset(mtxDump("/home/mseminario2/vestarv/implementations/asic/castalia/analog/data/raw/drive_map__tt111__verr.csv" (v("/V_OutOL")-v("/V_InP"))))
    errset(mtxDump("/home/mseminario2/vestarv/implementations/asic/castalia/analog/data/raw/drive_map__tt111__verr_q.csv" value((v("/V_OutOL")-v("/V_InP")) 0.0)))
  )
)

;; ---- corner 112 (ff112) / test drive_map
when(isDir("/home/mseminario2/chips/castalia/simarchive/anatop_tb_controlamp/Interactive.137/112/DriveMapTB/psf")
  openResults("/home/mseminario2/chips/castalia/simarchive/anatop_tb_controlamp/Interactive.137/112/DriveMapTB/psf")
  when(member('dc results())
    selectResult('dc)
    mtxP = outfile("/home/mseminario2/vestarv/implementations/asic/castalia/analog/data/raw/drive_map__ff112.meta" "w")
    fprintf(mtxP "sweep %%L\n" car(errset(sweepNames())))
    close(mtxP)
    errset(mtxDump("/home/mseminario2/vestarv/implementations/asic/castalia/analog/data/raw/drive_map__ff112__i_sink.csv" cross((v("/V_OutOL")-v("/V_InP")) 0.05 1 "falling")))
    errset(mtxDump("/home/mseminario2/vestarv/implementations/asic/castalia/analog/data/raw/drive_map__ff112__i_span.csv" (cross((v("/V_OutOL")-v("/V_InP")) -0.05 1 "falling")-cross((v("/V_OutOL")-v("/V_InP")) 0.05 1 "falling"))))
    errset(mtxDump("/home/mseminario2/vestarv/implementations/asic/castalia/analog/data/raw/drive_map__ff112__i_src.csv" cross((v("/V_OutOL")-v("/V_InP")) -0.05 1 "falling")))
    errset(mtxDump("/home/mseminario2/vestarv/implementations/asic/castalia/analog/data/raw/drive_map__ff112__idd_q.csv" value(abs(i("/POWER/SRC_VDD25/PLUS")) 0.0)))
    errset(mtxDump("/home/mseminario2/vestarv/implementations/asic/castalia/analog/data/raw/drive_map__ff112__rout.csv" abs((value(v("/V_OutOL") 0.5e-6)-value(v("/V_OutOL") -0.5e-6))/1e-6)))
    errset(mtxDump("/home/mseminario2/vestarv/implementations/asic/castalia/analog/data/raw/drive_map__ff112__verr.csv" (v("/V_OutOL")-v("/V_InP"))))
    errset(mtxDump("/home/mseminario2/vestarv/implementations/asic/castalia/analog/data/raw/drive_map__ff112__verr_q.csv" value((v("/V_OutOL")-v("/V_InP")) 0.0)))
  )
)

;; ---- corner 113 (fs113) / test drive_map
when(isDir("/home/mseminario2/chips/castalia/simarchive/anatop_tb_controlamp/Interactive.137/113/DriveMapTB/psf")
  openResults("/home/mseminario2/chips/castalia/simarchive/anatop_tb_controlamp/Interactive.137/113/DriveMapTB/psf")
  when(member('dc results())
    selectResult('dc)
    mtxP = outfile("/home/mseminario2/vestarv/implementations/asic/castalia/analog/data/raw/drive_map__fs113.meta" "w")
    fprintf(mtxP "sweep %%L\n" car(errset(sweepNames())))
    close(mtxP)
    errset(mtxDump("/home/mseminario2/vestarv/implementations/asic/castalia/analog/data/raw/drive_map__fs113__i_sink.csv" cross((v("/V_OutOL")-v("/V_InP")) 0.05 1 "falling")))
    errset(mtxDump("/home/mseminario2/vestarv/implementations/asic/castalia/analog/data/raw/drive_map__fs113__i_span.csv" (cross((v("/V_OutOL")-v("/V_InP")) -0.05 1 "falling")-cross((v("/V_OutOL")-v("/V_InP")) 0.05 1 "falling"))))
    errset(mtxDump("/home/mseminario2/vestarv/implementations/asic/castalia/analog/data/raw/drive_map__fs113__i_src.csv" cross((v("/V_OutOL")-v("/V_InP")) -0.05 1 "falling")))
    errset(mtxDump("/home/mseminario2/vestarv/implementations/asic/castalia/analog/data/raw/drive_map__fs113__idd_q.csv" value(abs(i("/POWER/SRC_VDD25/PLUS")) 0.0)))
    errset(mtxDump("/home/mseminario2/vestarv/implementations/asic/castalia/analog/data/raw/drive_map__fs113__rout.csv" abs((value(v("/V_OutOL") 0.5e-6)-value(v("/V_OutOL") -0.5e-6))/1e-6)))
    errset(mtxDump("/home/mseminario2/vestarv/implementations/asic/castalia/analog/data/raw/drive_map__fs113__verr.csv" (v("/V_OutOL")-v("/V_InP"))))
    errset(mtxDump("/home/mseminario2/vestarv/implementations/asic/castalia/analog/data/raw/drive_map__fs113__verr_q.csv" value((v("/V_OutOL")-v("/V_InP")) 0.0)))
  )
)

;; ---- corner 114 (sf114) / test drive_map
when(isDir("/home/mseminario2/chips/castalia/simarchive/anatop_tb_controlamp/Interactive.137/114/DriveMapTB/psf")
  openResults("/home/mseminario2/chips/castalia/simarchive/anatop_tb_controlamp/Interactive.137/114/DriveMapTB/psf")
  when(member('dc results())
    selectResult('dc)
    mtxP = outfile("/home/mseminario2/vestarv/implementations/asic/castalia/analog/data/raw/drive_map__sf114.meta" "w")
    fprintf(mtxP "sweep %%L\n" car(errset(sweepNames())))
    close(mtxP)
    errset(mtxDump("/home/mseminario2/vestarv/implementations/asic/castalia/analog/data/raw/drive_map__sf114__i_sink.csv" cross((v("/V_OutOL")-v("/V_InP")) 0.05 1 "falling")))
    errset(mtxDump("/home/mseminario2/vestarv/implementations/asic/castalia/analog/data/raw/drive_map__sf114__i_span.csv" (cross((v("/V_OutOL")-v("/V_InP")) -0.05 1 "falling")-cross((v("/V_OutOL")-v("/V_InP")) 0.05 1 "falling"))))
    errset(mtxDump("/home/mseminario2/vestarv/implementations/asic/castalia/analog/data/raw/drive_map__sf114__i_src.csv" cross((v("/V_OutOL")-v("/V_InP")) -0.05 1 "falling")))
    errset(mtxDump("/home/mseminario2/vestarv/implementations/asic/castalia/analog/data/raw/drive_map__sf114__idd_q.csv" value(abs(i("/POWER/SRC_VDD25/PLUS")) 0.0)))
    errset(mtxDump("/home/mseminario2/vestarv/implementations/asic/castalia/analog/data/raw/drive_map__sf114__rout.csv" abs((value(v("/V_OutOL") 0.5e-6)-value(v("/V_OutOL") -0.5e-6))/1e-6)))
    errset(mtxDump("/home/mseminario2/vestarv/implementations/asic/castalia/analog/data/raw/drive_map__sf114__verr.csv" (v("/V_OutOL")-v("/V_InP"))))
    errset(mtxDump("/home/mseminario2/vestarv/implementations/asic/castalia/analog/data/raw/drive_map__sf114__verr_q.csv" value((v("/V_OutOL")-v("/V_InP")) 0.0)))
  )
)

;; ---- corner 115 (ss115) / test drive_map
when(isDir("/home/mseminario2/chips/castalia/simarchive/anatop_tb_controlamp/Interactive.137/115/DriveMapTB/psf")
  openResults("/home/mseminario2/chips/castalia/simarchive/anatop_tb_controlamp/Interactive.137/115/DriveMapTB/psf")
  when(member('dc results())
    selectResult('dc)
    mtxP = outfile("/home/mseminario2/vestarv/implementations/asic/castalia/analog/data/raw/drive_map__ss115.meta" "w")
    fprintf(mtxP "sweep %%L\n" car(errset(sweepNames())))
    close(mtxP)
    errset(mtxDump("/home/mseminario2/vestarv/implementations/asic/castalia/analog/data/raw/drive_map__ss115__i_sink.csv" cross((v("/V_OutOL")-v("/V_InP")) 0.05 1 "falling")))
    errset(mtxDump("/home/mseminario2/vestarv/implementations/asic/castalia/analog/data/raw/drive_map__ss115__i_span.csv" (cross((v("/V_OutOL")-v("/V_InP")) -0.05 1 "falling")-cross((v("/V_OutOL")-v("/V_InP")) 0.05 1 "falling"))))
    errset(mtxDump("/home/mseminario2/vestarv/implementations/asic/castalia/analog/data/raw/drive_map__ss115__i_src.csv" cross((v("/V_OutOL")-v("/V_InP")) -0.05 1 "falling")))
    errset(mtxDump("/home/mseminario2/vestarv/implementations/asic/castalia/analog/data/raw/drive_map__ss115__idd_q.csv" value(abs(i("/POWER/SRC_VDD25/PLUS")) 0.0)))
    errset(mtxDump("/home/mseminario2/vestarv/implementations/asic/castalia/analog/data/raw/drive_map__ss115__rout.csv" abs((value(v("/V_OutOL") 0.5e-6)-value(v("/V_OutOL") -0.5e-6))/1e-6)))
    errset(mtxDump("/home/mseminario2/vestarv/implementations/asic/castalia/analog/data/raw/drive_map__ss115__verr.csv" (v("/V_OutOL")-v("/V_InP"))))
    errset(mtxDump("/home/mseminario2/vestarv/implementations/asic/castalia/analog/data/raw/drive_map__ss115__verr_q.csv" value((v("/V_OutOL")-v("/V_InP")) 0.0)))
  )
)

;; ---- corner 116 (tt116) / test drive_map
when(isDir("/home/mseminario2/chips/castalia/simarchive/anatop_tb_controlamp/Interactive.137/116/DriveMapTB/psf")
  openResults("/home/mseminario2/chips/castalia/simarchive/anatop_tb_controlamp/Interactive.137/116/DriveMapTB/psf")
  when(member('dc results())
    selectResult('dc)
    mtxP = outfile("/home/mseminario2/vestarv/implementations/asic/castalia/analog/data/raw/drive_map__tt116.meta" "w")
    fprintf(mtxP "sweep %%L\n" car(errset(sweepNames())))
    close(mtxP)
    errset(mtxDump("/home/mseminario2/vestarv/implementations/asic/castalia/analog/data/raw/drive_map__tt116__i_sink.csv" cross((v("/V_OutOL")-v("/V_InP")) 0.05 1 "falling")))
    errset(mtxDump("/home/mseminario2/vestarv/implementations/asic/castalia/analog/data/raw/drive_map__tt116__i_span.csv" (cross((v("/V_OutOL")-v("/V_InP")) -0.05 1 "falling")-cross((v("/V_OutOL")-v("/V_InP")) 0.05 1 "falling"))))
    errset(mtxDump("/home/mseminario2/vestarv/implementations/asic/castalia/analog/data/raw/drive_map__tt116__i_src.csv" cross((v("/V_OutOL")-v("/V_InP")) -0.05 1 "falling")))
    errset(mtxDump("/home/mseminario2/vestarv/implementations/asic/castalia/analog/data/raw/drive_map__tt116__idd_q.csv" value(abs(i("/POWER/SRC_VDD25/PLUS")) 0.0)))
    errset(mtxDump("/home/mseminario2/vestarv/implementations/asic/castalia/analog/data/raw/drive_map__tt116__rout.csv" abs((value(v("/V_OutOL") 0.5e-6)-value(v("/V_OutOL") -0.5e-6))/1e-6)))
    errset(mtxDump("/home/mseminario2/vestarv/implementations/asic/castalia/analog/data/raw/drive_map__tt116__verr.csv" (v("/V_OutOL")-v("/V_InP"))))
    errset(mtxDump("/home/mseminario2/vestarv/implementations/asic/castalia/analog/data/raw/drive_map__tt116__verr_q.csv" value((v("/V_OutOL")-v("/V_InP")) 0.0)))
  )
)

;; ---- corner 117 (ff117) / test drive_map
when(isDir("/home/mseminario2/chips/castalia/simarchive/anatop_tb_controlamp/Interactive.137/117/DriveMapTB/psf")
  openResults("/home/mseminario2/chips/castalia/simarchive/anatop_tb_controlamp/Interactive.137/117/DriveMapTB/psf")
  when(member('dc results())
    selectResult('dc)
    mtxP = outfile("/home/mseminario2/vestarv/implementations/asic/castalia/analog/data/raw/drive_map__ff117.meta" "w")
    fprintf(mtxP "sweep %%L\n" car(errset(sweepNames())))
    close(mtxP)
    errset(mtxDump("/home/mseminario2/vestarv/implementations/asic/castalia/analog/data/raw/drive_map__ff117__i_sink.csv" cross((v("/V_OutOL")-v("/V_InP")) 0.05 1 "falling")))
    errset(mtxDump("/home/mseminario2/vestarv/implementations/asic/castalia/analog/data/raw/drive_map__ff117__i_span.csv" (cross((v("/V_OutOL")-v("/V_InP")) -0.05 1 "falling")-cross((v("/V_OutOL")-v("/V_InP")) 0.05 1 "falling"))))
    errset(mtxDump("/home/mseminario2/vestarv/implementations/asic/castalia/analog/data/raw/drive_map__ff117__i_src.csv" cross((v("/V_OutOL")-v("/V_InP")) -0.05 1 "falling")))
    errset(mtxDump("/home/mseminario2/vestarv/implementations/asic/castalia/analog/data/raw/drive_map__ff117__idd_q.csv" value(abs(i("/POWER/SRC_VDD25/PLUS")) 0.0)))
    errset(mtxDump("/home/mseminario2/vestarv/implementations/asic/castalia/analog/data/raw/drive_map__ff117__rout.csv" abs((value(v("/V_OutOL") 0.5e-6)-value(v("/V_OutOL") -0.5e-6))/1e-6)))
    errset(mtxDump("/home/mseminario2/vestarv/implementations/asic/castalia/analog/data/raw/drive_map__ff117__verr.csv" (v("/V_OutOL")-v("/V_InP"))))
    errset(mtxDump("/home/mseminario2/vestarv/implementations/asic/castalia/analog/data/raw/drive_map__ff117__verr_q.csv" value((v("/V_OutOL")-v("/V_InP")) 0.0)))
  )
)

;; ---- corner 118 (fs118) / test drive_map
when(isDir("/home/mseminario2/chips/castalia/simarchive/anatop_tb_controlamp/Interactive.137/118/DriveMapTB/psf")
  openResults("/home/mseminario2/chips/castalia/simarchive/anatop_tb_controlamp/Interactive.137/118/DriveMapTB/psf")
  when(member('dc results())
    selectResult('dc)
    mtxP = outfile("/home/mseminario2/vestarv/implementations/asic/castalia/analog/data/raw/drive_map__fs118.meta" "w")
    fprintf(mtxP "sweep %%L\n" car(errset(sweepNames())))
    close(mtxP)
    errset(mtxDump("/home/mseminario2/vestarv/implementations/asic/castalia/analog/data/raw/drive_map__fs118__i_sink.csv" cross((v("/V_OutOL")-v("/V_InP")) 0.05 1 "falling")))
    errset(mtxDump("/home/mseminario2/vestarv/implementations/asic/castalia/analog/data/raw/drive_map__fs118__i_span.csv" (cross((v("/V_OutOL")-v("/V_InP")) -0.05 1 "falling")-cross((v("/V_OutOL")-v("/V_InP")) 0.05 1 "falling"))))
    errset(mtxDump("/home/mseminario2/vestarv/implementations/asic/castalia/analog/data/raw/drive_map__fs118__i_src.csv" cross((v("/V_OutOL")-v("/V_InP")) -0.05 1 "falling")))
    errset(mtxDump("/home/mseminario2/vestarv/implementations/asic/castalia/analog/data/raw/drive_map__fs118__idd_q.csv" value(abs(i("/POWER/SRC_VDD25/PLUS")) 0.0)))
    errset(mtxDump("/home/mseminario2/vestarv/implementations/asic/castalia/analog/data/raw/drive_map__fs118__rout.csv" abs((value(v("/V_OutOL") 0.5e-6)-value(v("/V_OutOL") -0.5e-6))/1e-6)))
    errset(mtxDump("/home/mseminario2/vestarv/implementations/asic/castalia/analog/data/raw/drive_map__fs118__verr.csv" (v("/V_OutOL")-v("/V_InP"))))
    errset(mtxDump("/home/mseminario2/vestarv/implementations/asic/castalia/analog/data/raw/drive_map__fs118__verr_q.csv" value((v("/V_OutOL")-v("/V_InP")) 0.0)))
  )
)

;; ---- corner 119 (sf119) / test drive_map
when(isDir("/home/mseminario2/chips/castalia/simarchive/anatop_tb_controlamp/Interactive.137/119/DriveMapTB/psf")
  openResults("/home/mseminario2/chips/castalia/simarchive/anatop_tb_controlamp/Interactive.137/119/DriveMapTB/psf")
  when(member('dc results())
    selectResult('dc)
    mtxP = outfile("/home/mseminario2/vestarv/implementations/asic/castalia/analog/data/raw/drive_map__sf119.meta" "w")
    fprintf(mtxP "sweep %%L\n" car(errset(sweepNames())))
    close(mtxP)
    errset(mtxDump("/home/mseminario2/vestarv/implementations/asic/castalia/analog/data/raw/drive_map__sf119__i_sink.csv" cross((v("/V_OutOL")-v("/V_InP")) 0.05 1 "falling")))
    errset(mtxDump("/home/mseminario2/vestarv/implementations/asic/castalia/analog/data/raw/drive_map__sf119__i_span.csv" (cross((v("/V_OutOL")-v("/V_InP")) -0.05 1 "falling")-cross((v("/V_OutOL")-v("/V_InP")) 0.05 1 "falling"))))
    errset(mtxDump("/home/mseminario2/vestarv/implementations/asic/castalia/analog/data/raw/drive_map__sf119__i_src.csv" cross((v("/V_OutOL")-v("/V_InP")) -0.05 1 "falling")))
    errset(mtxDump("/home/mseminario2/vestarv/implementations/asic/castalia/analog/data/raw/drive_map__sf119__idd_q.csv" value(abs(i("/POWER/SRC_VDD25/PLUS")) 0.0)))
    errset(mtxDump("/home/mseminario2/vestarv/implementations/asic/castalia/analog/data/raw/drive_map__sf119__rout.csv" abs((value(v("/V_OutOL") 0.5e-6)-value(v("/V_OutOL") -0.5e-6))/1e-6)))
    errset(mtxDump("/home/mseminario2/vestarv/implementations/asic/castalia/analog/data/raw/drive_map__sf119__verr.csv" (v("/V_OutOL")-v("/V_InP"))))
    errset(mtxDump("/home/mseminario2/vestarv/implementations/asic/castalia/analog/data/raw/drive_map__sf119__verr_q.csv" value((v("/V_OutOL")-v("/V_InP")) 0.0)))
  )
)

;; ---- corner 120 (ss120) / test drive_map
when(isDir("/home/mseminario2/chips/castalia/simarchive/anatop_tb_controlamp/Interactive.137/120/DriveMapTB/psf")
  openResults("/home/mseminario2/chips/castalia/simarchive/anatop_tb_controlamp/Interactive.137/120/DriveMapTB/psf")
  when(member('dc results())
    selectResult('dc)
    mtxP = outfile("/home/mseminario2/vestarv/implementations/asic/castalia/analog/data/raw/drive_map__ss120.meta" "w")
    fprintf(mtxP "sweep %%L\n" car(errset(sweepNames())))
    close(mtxP)
    errset(mtxDump("/home/mseminario2/vestarv/implementations/asic/castalia/analog/data/raw/drive_map__ss120__i_sink.csv" cross((v("/V_OutOL")-v("/V_InP")) 0.05 1 "falling")))
    errset(mtxDump("/home/mseminario2/vestarv/implementations/asic/castalia/analog/data/raw/drive_map__ss120__i_span.csv" (cross((v("/V_OutOL")-v("/V_InP")) -0.05 1 "falling")-cross((v("/V_OutOL")-v("/V_InP")) 0.05 1 "falling"))))
    errset(mtxDump("/home/mseminario2/vestarv/implementations/asic/castalia/analog/data/raw/drive_map__ss120__i_src.csv" cross((v("/V_OutOL")-v("/V_InP")) -0.05 1 "falling")))
    errset(mtxDump("/home/mseminario2/vestarv/implementations/asic/castalia/analog/data/raw/drive_map__ss120__idd_q.csv" value(abs(i("/POWER/SRC_VDD25/PLUS")) 0.0)))
    errset(mtxDump("/home/mseminario2/vestarv/implementations/asic/castalia/analog/data/raw/drive_map__ss120__rout.csv" abs((value(v("/V_OutOL") 0.5e-6)-value(v("/V_OutOL") -0.5e-6))/1e-6)))
    errset(mtxDump("/home/mseminario2/vestarv/implementations/asic/castalia/analog/data/raw/drive_map__ss120__verr.csv" (v("/V_OutOL")-v("/V_InP"))))
    errset(mtxDump("/home/mseminario2/vestarv/implementations/asic/castalia/analog/data/raw/drive_map__ss120__verr_q.csv" value((v("/V_OutOL")-v("/V_InP")) 0.0)))
  )
)

;; ---- corner 121 (tt121) / test drive_map
when(isDir("/home/mseminario2/chips/castalia/simarchive/anatop_tb_controlamp/Interactive.137/121/DriveMapTB/psf")
  openResults("/home/mseminario2/chips/castalia/simarchive/anatop_tb_controlamp/Interactive.137/121/DriveMapTB/psf")
  when(member('dc results())
    selectResult('dc)
    mtxP = outfile("/home/mseminario2/vestarv/implementations/asic/castalia/analog/data/raw/drive_map__tt121.meta" "w")
    fprintf(mtxP "sweep %%L\n" car(errset(sweepNames())))
    close(mtxP)
    errset(mtxDump("/home/mseminario2/vestarv/implementations/asic/castalia/analog/data/raw/drive_map__tt121__i_sink.csv" cross((v("/V_OutOL")-v("/V_InP")) 0.05 1 "falling")))
    errset(mtxDump("/home/mseminario2/vestarv/implementations/asic/castalia/analog/data/raw/drive_map__tt121__i_span.csv" (cross((v("/V_OutOL")-v("/V_InP")) -0.05 1 "falling")-cross((v("/V_OutOL")-v("/V_InP")) 0.05 1 "falling"))))
    errset(mtxDump("/home/mseminario2/vestarv/implementations/asic/castalia/analog/data/raw/drive_map__tt121__i_src.csv" cross((v("/V_OutOL")-v("/V_InP")) -0.05 1 "falling")))
    errset(mtxDump("/home/mseminario2/vestarv/implementations/asic/castalia/analog/data/raw/drive_map__tt121__idd_q.csv" value(abs(i("/POWER/SRC_VDD25/PLUS")) 0.0)))
    errset(mtxDump("/home/mseminario2/vestarv/implementations/asic/castalia/analog/data/raw/drive_map__tt121__rout.csv" abs((value(v("/V_OutOL") 0.5e-6)-value(v("/V_OutOL") -0.5e-6))/1e-6)))
    errset(mtxDump("/home/mseminario2/vestarv/implementations/asic/castalia/analog/data/raw/drive_map__tt121__verr.csv" (v("/V_OutOL")-v("/V_InP"))))
    errset(mtxDump("/home/mseminario2/vestarv/implementations/asic/castalia/analog/data/raw/drive_map__tt121__verr_q.csv" value((v("/V_OutOL")-v("/V_InP")) 0.0)))
  )
)

;; ---- corner 122 (ff122) / test drive_map
when(isDir("/home/mseminario2/chips/castalia/simarchive/anatop_tb_controlamp/Interactive.137/122/DriveMapTB/psf")
  openResults("/home/mseminario2/chips/castalia/simarchive/anatop_tb_controlamp/Interactive.137/122/DriveMapTB/psf")
  when(member('dc results())
    selectResult('dc)
    mtxP = outfile("/home/mseminario2/vestarv/implementations/asic/castalia/analog/data/raw/drive_map__ff122.meta" "w")
    fprintf(mtxP "sweep %%L\n" car(errset(sweepNames())))
    close(mtxP)
    errset(mtxDump("/home/mseminario2/vestarv/implementations/asic/castalia/analog/data/raw/drive_map__ff122__i_sink.csv" cross((v("/V_OutOL")-v("/V_InP")) 0.05 1 "falling")))
    errset(mtxDump("/home/mseminario2/vestarv/implementations/asic/castalia/analog/data/raw/drive_map__ff122__i_span.csv" (cross((v("/V_OutOL")-v("/V_InP")) -0.05 1 "falling")-cross((v("/V_OutOL")-v("/V_InP")) 0.05 1 "falling"))))
    errset(mtxDump("/home/mseminario2/vestarv/implementations/asic/castalia/analog/data/raw/drive_map__ff122__i_src.csv" cross((v("/V_OutOL")-v("/V_InP")) -0.05 1 "falling")))
    errset(mtxDump("/home/mseminario2/vestarv/implementations/asic/castalia/analog/data/raw/drive_map__ff122__idd_q.csv" value(abs(i("/POWER/SRC_VDD25/PLUS")) 0.0)))
    errset(mtxDump("/home/mseminario2/vestarv/implementations/asic/castalia/analog/data/raw/drive_map__ff122__rout.csv" abs((value(v("/V_OutOL") 0.5e-6)-value(v("/V_OutOL") -0.5e-6))/1e-6)))
    errset(mtxDump("/home/mseminario2/vestarv/implementations/asic/castalia/analog/data/raw/drive_map__ff122__verr.csv" (v("/V_OutOL")-v("/V_InP"))))
    errset(mtxDump("/home/mseminario2/vestarv/implementations/asic/castalia/analog/data/raw/drive_map__ff122__verr_q.csv" value((v("/V_OutOL")-v("/V_InP")) 0.0)))
  )
)

;; ---- corner 123 (fs123) / test drive_map
when(isDir("/home/mseminario2/chips/castalia/simarchive/anatop_tb_controlamp/Interactive.137/123/DriveMapTB/psf")
  openResults("/home/mseminario2/chips/castalia/simarchive/anatop_tb_controlamp/Interactive.137/123/DriveMapTB/psf")
  when(member('dc results())
    selectResult('dc)
    mtxP = outfile("/home/mseminario2/vestarv/implementations/asic/castalia/analog/data/raw/drive_map__fs123.meta" "w")
    fprintf(mtxP "sweep %%L\n" car(errset(sweepNames())))
    close(mtxP)
    errset(mtxDump("/home/mseminario2/vestarv/implementations/asic/castalia/analog/data/raw/drive_map__fs123__i_sink.csv" cross((v("/V_OutOL")-v("/V_InP")) 0.05 1 "falling")))
    errset(mtxDump("/home/mseminario2/vestarv/implementations/asic/castalia/analog/data/raw/drive_map__fs123__i_span.csv" (cross((v("/V_OutOL")-v("/V_InP")) -0.05 1 "falling")-cross((v("/V_OutOL")-v("/V_InP")) 0.05 1 "falling"))))
    errset(mtxDump("/home/mseminario2/vestarv/implementations/asic/castalia/analog/data/raw/drive_map__fs123__i_src.csv" cross((v("/V_OutOL")-v("/V_InP")) -0.05 1 "falling")))
    errset(mtxDump("/home/mseminario2/vestarv/implementations/asic/castalia/analog/data/raw/drive_map__fs123__idd_q.csv" value(abs(i("/POWER/SRC_VDD25/PLUS")) 0.0)))
    errset(mtxDump("/home/mseminario2/vestarv/implementations/asic/castalia/analog/data/raw/drive_map__fs123__rout.csv" abs((value(v("/V_OutOL") 0.5e-6)-value(v("/V_OutOL") -0.5e-6))/1e-6)))
    errset(mtxDump("/home/mseminario2/vestarv/implementations/asic/castalia/analog/data/raw/drive_map__fs123__verr.csv" (v("/V_OutOL")-v("/V_InP"))))
    errset(mtxDump("/home/mseminario2/vestarv/implementations/asic/castalia/analog/data/raw/drive_map__fs123__verr_q.csv" value((v("/V_OutOL")-v("/V_InP")) 0.0)))
  )
)

;; ---- corner 124 (sf124) / test drive_map
when(isDir("/home/mseminario2/chips/castalia/simarchive/anatop_tb_controlamp/Interactive.137/124/DriveMapTB/psf")
  openResults("/home/mseminario2/chips/castalia/simarchive/anatop_tb_controlamp/Interactive.137/124/DriveMapTB/psf")
  when(member('dc results())
    selectResult('dc)
    mtxP = outfile("/home/mseminario2/vestarv/implementations/asic/castalia/analog/data/raw/drive_map__sf124.meta" "w")
    fprintf(mtxP "sweep %%L\n" car(errset(sweepNames())))
    close(mtxP)
    errset(mtxDump("/home/mseminario2/vestarv/implementations/asic/castalia/analog/data/raw/drive_map__sf124__i_sink.csv" cross((v("/V_OutOL")-v("/V_InP")) 0.05 1 "falling")))
    errset(mtxDump("/home/mseminario2/vestarv/implementations/asic/castalia/analog/data/raw/drive_map__sf124__i_span.csv" (cross((v("/V_OutOL")-v("/V_InP")) -0.05 1 "falling")-cross((v("/V_OutOL")-v("/V_InP")) 0.05 1 "falling"))))
    errset(mtxDump("/home/mseminario2/vestarv/implementations/asic/castalia/analog/data/raw/drive_map__sf124__i_src.csv" cross((v("/V_OutOL")-v("/V_InP")) -0.05 1 "falling")))
    errset(mtxDump("/home/mseminario2/vestarv/implementations/asic/castalia/analog/data/raw/drive_map__sf124__idd_q.csv" value(abs(i("/POWER/SRC_VDD25/PLUS")) 0.0)))
    errset(mtxDump("/home/mseminario2/vestarv/implementations/asic/castalia/analog/data/raw/drive_map__sf124__rout.csv" abs((value(v("/V_OutOL") 0.5e-6)-value(v("/V_OutOL") -0.5e-6))/1e-6)))
    errset(mtxDump("/home/mseminario2/vestarv/implementations/asic/castalia/analog/data/raw/drive_map__sf124__verr.csv" (v("/V_OutOL")-v("/V_InP"))))
    errset(mtxDump("/home/mseminario2/vestarv/implementations/asic/castalia/analog/data/raw/drive_map__sf124__verr_q.csv" value((v("/V_OutOL")-v("/V_InP")) 0.0)))
  )
)

;; ---- corner 125 (ss125) / test drive_map
when(isDir("/home/mseminario2/chips/castalia/simarchive/anatop_tb_controlamp/Interactive.137/125/DriveMapTB/psf")
  openResults("/home/mseminario2/chips/castalia/simarchive/anatop_tb_controlamp/Interactive.137/125/DriveMapTB/psf")
  when(member('dc results())
    selectResult('dc)
    mtxP = outfile("/home/mseminario2/vestarv/implementations/asic/castalia/analog/data/raw/drive_map__ss125.meta" "w")
    fprintf(mtxP "sweep %%L\n" car(errset(sweepNames())))
    close(mtxP)
    errset(mtxDump("/home/mseminario2/vestarv/implementations/asic/castalia/analog/data/raw/drive_map__ss125__i_sink.csv" cross((v("/V_OutOL")-v("/V_InP")) 0.05 1 "falling")))
    errset(mtxDump("/home/mseminario2/vestarv/implementations/asic/castalia/analog/data/raw/drive_map__ss125__i_span.csv" (cross((v("/V_OutOL")-v("/V_InP")) -0.05 1 "falling")-cross((v("/V_OutOL")-v("/V_InP")) 0.05 1 "falling"))))
    errset(mtxDump("/home/mseminario2/vestarv/implementations/asic/castalia/analog/data/raw/drive_map__ss125__i_src.csv" cross((v("/V_OutOL")-v("/V_InP")) -0.05 1 "falling")))
    errset(mtxDump("/home/mseminario2/vestarv/implementations/asic/castalia/analog/data/raw/drive_map__ss125__idd_q.csv" value(abs(i("/POWER/SRC_VDD25/PLUS")) 0.0)))
    errset(mtxDump("/home/mseminario2/vestarv/implementations/asic/castalia/analog/data/raw/drive_map__ss125__rout.csv" abs((value(v("/V_OutOL") 0.5e-6)-value(v("/V_OutOL") -0.5e-6))/1e-6)))
    errset(mtxDump("/home/mseminario2/vestarv/implementations/asic/castalia/analog/data/raw/drive_map__ss125__verr.csv" (v("/V_OutOL")-v("/V_InP"))))
    errset(mtxDump("/home/mseminario2/vestarv/implementations/asic/castalia/analog/data/raw/drive_map__ss125__verr_q.csv" value((v("/V_OutOL")-v("/V_InP")) 0.0)))
  )
)

;; ---- corner 126 (tt126) / test drive_map
when(isDir("/home/mseminario2/chips/castalia/simarchive/anatop_tb_controlamp/Interactive.137/126/DriveMapTB/psf")
  openResults("/home/mseminario2/chips/castalia/simarchive/anatop_tb_controlamp/Interactive.137/126/DriveMapTB/psf")
  when(member('dc results())
    selectResult('dc)
    mtxP = outfile("/home/mseminario2/vestarv/implementations/asic/castalia/analog/data/raw/drive_map__tt126.meta" "w")
    fprintf(mtxP "sweep %%L\n" car(errset(sweepNames())))
    close(mtxP)
    errset(mtxDump("/home/mseminario2/vestarv/implementations/asic/castalia/analog/data/raw/drive_map__tt126__i_sink.csv" cross((v("/V_OutOL")-v("/V_InP")) 0.05 1 "falling")))
    errset(mtxDump("/home/mseminario2/vestarv/implementations/asic/castalia/analog/data/raw/drive_map__tt126__i_span.csv" (cross((v("/V_OutOL")-v("/V_InP")) -0.05 1 "falling")-cross((v("/V_OutOL")-v("/V_InP")) 0.05 1 "falling"))))
    errset(mtxDump("/home/mseminario2/vestarv/implementations/asic/castalia/analog/data/raw/drive_map__tt126__i_src.csv" cross((v("/V_OutOL")-v("/V_InP")) -0.05 1 "falling")))
    errset(mtxDump("/home/mseminario2/vestarv/implementations/asic/castalia/analog/data/raw/drive_map__tt126__idd_q.csv" value(abs(i("/POWER/SRC_VDD25/PLUS")) 0.0)))
    errset(mtxDump("/home/mseminario2/vestarv/implementations/asic/castalia/analog/data/raw/drive_map__tt126__rout.csv" abs((value(v("/V_OutOL") 0.5e-6)-value(v("/V_OutOL") -0.5e-6))/1e-6)))
    errset(mtxDump("/home/mseminario2/vestarv/implementations/asic/castalia/analog/data/raw/drive_map__tt126__verr.csv" (v("/V_OutOL")-v("/V_InP"))))
    errset(mtxDump("/home/mseminario2/vestarv/implementations/asic/castalia/analog/data/raw/drive_map__tt126__verr_q.csv" value((v("/V_OutOL")-v("/V_InP")) 0.0)))
  )
)

;; ---- corner 127 (ff127) / test drive_map
when(isDir("/home/mseminario2/chips/castalia/simarchive/anatop_tb_controlamp/Interactive.137/127/DriveMapTB/psf")
  openResults("/home/mseminario2/chips/castalia/simarchive/anatop_tb_controlamp/Interactive.137/127/DriveMapTB/psf")
  when(member('dc results())
    selectResult('dc)
    mtxP = outfile("/home/mseminario2/vestarv/implementations/asic/castalia/analog/data/raw/drive_map__ff127.meta" "w")
    fprintf(mtxP "sweep %%L\n" car(errset(sweepNames())))
    close(mtxP)
    errset(mtxDump("/home/mseminario2/vestarv/implementations/asic/castalia/analog/data/raw/drive_map__ff127__i_sink.csv" cross((v("/V_OutOL")-v("/V_InP")) 0.05 1 "falling")))
    errset(mtxDump("/home/mseminario2/vestarv/implementations/asic/castalia/analog/data/raw/drive_map__ff127__i_span.csv" (cross((v("/V_OutOL")-v("/V_InP")) -0.05 1 "falling")-cross((v("/V_OutOL")-v("/V_InP")) 0.05 1 "falling"))))
    errset(mtxDump("/home/mseminario2/vestarv/implementations/asic/castalia/analog/data/raw/drive_map__ff127__i_src.csv" cross((v("/V_OutOL")-v("/V_InP")) -0.05 1 "falling")))
    errset(mtxDump("/home/mseminario2/vestarv/implementations/asic/castalia/analog/data/raw/drive_map__ff127__idd_q.csv" value(abs(i("/POWER/SRC_VDD25/PLUS")) 0.0)))
    errset(mtxDump("/home/mseminario2/vestarv/implementations/asic/castalia/analog/data/raw/drive_map__ff127__rout.csv" abs((value(v("/V_OutOL") 0.5e-6)-value(v("/V_OutOL") -0.5e-6))/1e-6)))
    errset(mtxDump("/home/mseminario2/vestarv/implementations/asic/castalia/analog/data/raw/drive_map__ff127__verr.csv" (v("/V_OutOL")-v("/V_InP"))))
    errset(mtxDump("/home/mseminario2/vestarv/implementations/asic/castalia/analog/data/raw/drive_map__ff127__verr_q.csv" value((v("/V_OutOL")-v("/V_InP")) 0.0)))
  )
)

;; ---- corner 128 (fs128) / test drive_map
when(isDir("/home/mseminario2/chips/castalia/simarchive/anatop_tb_controlamp/Interactive.137/128/DriveMapTB/psf")
  openResults("/home/mseminario2/chips/castalia/simarchive/anatop_tb_controlamp/Interactive.137/128/DriveMapTB/psf")
  when(member('dc results())
    selectResult('dc)
    mtxP = outfile("/home/mseminario2/vestarv/implementations/asic/castalia/analog/data/raw/drive_map__fs128.meta" "w")
    fprintf(mtxP "sweep %%L\n" car(errset(sweepNames())))
    close(mtxP)
    errset(mtxDump("/home/mseminario2/vestarv/implementations/asic/castalia/analog/data/raw/drive_map__fs128__i_sink.csv" cross((v("/V_OutOL")-v("/V_InP")) 0.05 1 "falling")))
    errset(mtxDump("/home/mseminario2/vestarv/implementations/asic/castalia/analog/data/raw/drive_map__fs128__i_span.csv" (cross((v("/V_OutOL")-v("/V_InP")) -0.05 1 "falling")-cross((v("/V_OutOL")-v("/V_InP")) 0.05 1 "falling"))))
    errset(mtxDump("/home/mseminario2/vestarv/implementations/asic/castalia/analog/data/raw/drive_map__fs128__i_src.csv" cross((v("/V_OutOL")-v("/V_InP")) -0.05 1 "falling")))
    errset(mtxDump("/home/mseminario2/vestarv/implementations/asic/castalia/analog/data/raw/drive_map__fs128__idd_q.csv" value(abs(i("/POWER/SRC_VDD25/PLUS")) 0.0)))
    errset(mtxDump("/home/mseminario2/vestarv/implementations/asic/castalia/analog/data/raw/drive_map__fs128__rout.csv" abs((value(v("/V_OutOL") 0.5e-6)-value(v("/V_OutOL") -0.5e-6))/1e-6)))
    errset(mtxDump("/home/mseminario2/vestarv/implementations/asic/castalia/analog/data/raw/drive_map__fs128__verr.csv" (v("/V_OutOL")-v("/V_InP"))))
    errset(mtxDump("/home/mseminario2/vestarv/implementations/asic/castalia/analog/data/raw/drive_map__fs128__verr_q.csv" value((v("/V_OutOL")-v("/V_InP")) 0.0)))
  )
)

;; ---- corner 129 (sf129) / test drive_map
when(isDir("/home/mseminario2/chips/castalia/simarchive/anatop_tb_controlamp/Interactive.137/129/DriveMapTB/psf")
  openResults("/home/mseminario2/chips/castalia/simarchive/anatop_tb_controlamp/Interactive.137/129/DriveMapTB/psf")
  when(member('dc results())
    selectResult('dc)
    mtxP = outfile("/home/mseminario2/vestarv/implementations/asic/castalia/analog/data/raw/drive_map__sf129.meta" "w")
    fprintf(mtxP "sweep %%L\n" car(errset(sweepNames())))
    close(mtxP)
    errset(mtxDump("/home/mseminario2/vestarv/implementations/asic/castalia/analog/data/raw/drive_map__sf129__i_sink.csv" cross((v("/V_OutOL")-v("/V_InP")) 0.05 1 "falling")))
    errset(mtxDump("/home/mseminario2/vestarv/implementations/asic/castalia/analog/data/raw/drive_map__sf129__i_span.csv" (cross((v("/V_OutOL")-v("/V_InP")) -0.05 1 "falling")-cross((v("/V_OutOL")-v("/V_InP")) 0.05 1 "falling"))))
    errset(mtxDump("/home/mseminario2/vestarv/implementations/asic/castalia/analog/data/raw/drive_map__sf129__i_src.csv" cross((v("/V_OutOL")-v("/V_InP")) -0.05 1 "falling")))
    errset(mtxDump("/home/mseminario2/vestarv/implementations/asic/castalia/analog/data/raw/drive_map__sf129__idd_q.csv" value(abs(i("/POWER/SRC_VDD25/PLUS")) 0.0)))
    errset(mtxDump("/home/mseminario2/vestarv/implementations/asic/castalia/analog/data/raw/drive_map__sf129__rout.csv" abs((value(v("/V_OutOL") 0.5e-6)-value(v("/V_OutOL") -0.5e-6))/1e-6)))
    errset(mtxDump("/home/mseminario2/vestarv/implementations/asic/castalia/analog/data/raw/drive_map__sf129__verr.csv" (v("/V_OutOL")-v("/V_InP"))))
    errset(mtxDump("/home/mseminario2/vestarv/implementations/asic/castalia/analog/data/raw/drive_map__sf129__verr_q.csv" value((v("/V_OutOL")-v("/V_InP")) 0.0)))
  )
)

;; ---- corner 130 (ss130) / test drive_map
when(isDir("/home/mseminario2/chips/castalia/simarchive/anatop_tb_controlamp/Interactive.137/130/DriveMapTB/psf")
  openResults("/home/mseminario2/chips/castalia/simarchive/anatop_tb_controlamp/Interactive.137/130/DriveMapTB/psf")
  when(member('dc results())
    selectResult('dc)
    mtxP = outfile("/home/mseminario2/vestarv/implementations/asic/castalia/analog/data/raw/drive_map__ss130.meta" "w")
    fprintf(mtxP "sweep %%L\n" car(errset(sweepNames())))
    close(mtxP)
    errset(mtxDump("/home/mseminario2/vestarv/implementations/asic/castalia/analog/data/raw/drive_map__ss130__i_sink.csv" cross((v("/V_OutOL")-v("/V_InP")) 0.05 1 "falling")))
    errset(mtxDump("/home/mseminario2/vestarv/implementations/asic/castalia/analog/data/raw/drive_map__ss130__i_span.csv" (cross((v("/V_OutOL")-v("/V_InP")) -0.05 1 "falling")-cross((v("/V_OutOL")-v("/V_InP")) 0.05 1 "falling"))))
    errset(mtxDump("/home/mseminario2/vestarv/implementations/asic/castalia/analog/data/raw/drive_map__ss130__i_src.csv" cross((v("/V_OutOL")-v("/V_InP")) -0.05 1 "falling")))
    errset(mtxDump("/home/mseminario2/vestarv/implementations/asic/castalia/analog/data/raw/drive_map__ss130__idd_q.csv" value(abs(i("/POWER/SRC_VDD25/PLUS")) 0.0)))
    errset(mtxDump("/home/mseminario2/vestarv/implementations/asic/castalia/analog/data/raw/drive_map__ss130__rout.csv" abs((value(v("/V_OutOL") 0.5e-6)-value(v("/V_OutOL") -0.5e-6))/1e-6)))
    errset(mtxDump("/home/mseminario2/vestarv/implementations/asic/castalia/analog/data/raw/drive_map__ss130__verr.csv" (v("/V_OutOL")-v("/V_InP"))))
    errset(mtxDump("/home/mseminario2/vestarv/implementations/asic/castalia/analog/data/raw/drive_map__ss130__verr_q.csv" value((v("/V_OutOL")-v("/V_InP")) 0.0)))
  )
)

printf("MTX_EXTRACT_DONE\n")
exit(0)
