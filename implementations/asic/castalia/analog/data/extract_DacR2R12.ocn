;; generated by maestro2tex -- do not edit
procedure(mtxDump(fname wv)
  let((xs ys n p)
    p = outfile(fname "w")
    cond(
      (null(wv) fprintf(p "#nil\n"))
      (drIsWaveform(wv)
        xs = drGetWaveformXVec(wv)
        ys = drGetWaveformYVec(wv)
        n = drVectorLength(xs)
        for(i 0 n-1
          fprintf(p "%.10g %.10g\n" drGetElem(xs i) drGetElem(ys i)))
      )
      (t fprintf(p "#scalar %.10g\n" float(wv)))
    )
    close(p)
    t))

;; ---- corner 1 (tt) / test dr_ideal
when(isDir("/home/mseminario2/chips/castalia/ic/.simulation/castalia/tb_anatop_pixel_dacR2R12/maestro/results/maestro/Interactive.34/1/DacNonlinTB/psf")
  openResults("/home/mseminario2/chips/castalia/ic/.simulation/castalia/tb_anatop_pixel_dacR2R12/maestro/results/maestro/Interactive.34/1/DacNonlinTB/psf")
  when(member('dc results())
    selectResult('dc)
    mtxP = outfile("/home/mseminario2/vestarv/implementations/asic/castalia/analog/data/raw/dr_ideal__tt.meta" "w")
    fprintf(mtxP "sweep %%L\n" car(errset(sweepNames())))
    close(mtxP)
    errset(mtxDump("/home/mseminario2/vestarv/implementations/asic/castalia/analog/data/raw/dr_ideal__tt__dnl_lsb.csv" ymax(abs(((deriv(VS("/Out")) / ((value(VS("/Out") 4095) - value(VS("/Out") 0)) / 4095)) - 1)))))
    errset(mtxDump("/home/mseminario2/vestarv/implementations/asic/castalia/analog/data/raw/dr_ideal__tt__dnl_max.csv" ymax(((deriv(VS("/Out")) / ((value(VS("/Out") 4095) - value(VS("/Out") 0)) / 4095)) - 1))))
    errset(mtxDump("/home/mseminario2/vestarv/implementations/asic/castalia/analog/data/raw/dr_ideal__tt__dnl_min.csv" ymin(((deriv(VS("/Out")) / ((value(VS("/Out") 4095) - value(VS("/Out") 0)) / 4095)) - 1))))
    errset(mtxDump("/home/mseminario2/vestarv/implementations/asic/castalia/analog/data/raw/dr_ideal__tt__dnl_wave.csv" ((deriv(VS("/Out")) / ((value(VS("/Out") 4095) - value(VS("/Out") 0)) / 4095)) - 1)))
    errset(mtxDump("/home/mseminario2/vestarv/implementations/asic/castalia/analog/data/raw/dr_ideal__tt__inl_lsb.csv" ymax(abs(((VS("/Out") - (value(VS("/Out") 0) + (((value(VS("/Out") 4095) - value(VS("/Out") 0)) / 4095) * xval(VS("/Out"))))) / ((value(VS("/Out") 4095) - value(VS("/Out") 0)) / 4095))))))
    errset(mtxDump("/home/mseminario2/vestarv/implementations/asic/castalia/analog/data/raw/dr_ideal__tt__inl_max.csv" ymax(((VS("/Out") - (value(VS("/Out") 0) + (((value(VS("/Out") 4095) - value(VS("/Out") 0)) / 4095) * xval(VS("/Out"))))) / ((value(VS("/Out") 4095) - value(VS("/Out") 0)) / 4095)))))
    errset(mtxDump("/home/mseminario2/vestarv/implementations/asic/castalia/analog/data/raw/dr_ideal__tt__inl_min.csv" ymin(((VS("/Out") - (value(VS("/Out") 0) + (((value(VS("/Out") 4095) - value(VS("/Out") 0)) / 4095) * xval(VS("/Out"))))) / ((value(VS("/Out") 4095) - value(VS("/Out") 0)) / 4095)))))
    errset(mtxDump("/home/mseminario2/vestarv/implementations/asic/castalia/analog/data/raw/dr_ideal__tt__inl_wave.csv" ((VS("/Out") - (value(VS("/Out") 0) + (((value(VS("/Out") 4095) - value(VS("/Out") 0)) / 4095) * xval(VS("/Out"))))) / ((value(VS("/Out") 4095) - value(VS("/Out") 0)) / 4095))))
    errset(mtxDump("/home/mseminario2/vestarv/implementations/asic/castalia/analog/data/raw/dr_ideal__tt__lsb.csv" ((value(VS("/Out") 4095) - value(VS("/Out") 0)) / 4095)))
    errset(mtxDump("/home/mseminario2/vestarv/implementations/asic/castalia/analog/data/raw/dr_ideal__tt__v_fs.csv" value(VS("/Out") 4095)))
    errset(mtxDump("/home/mseminario2/vestarv/implementations/asic/castalia/analog/data/raw/dr_ideal__tt__v_zs.csv" value(VS("/Out") 0)))
  )
)

;; ---- corner 1 (tt) / test dr_line
when(isDir("/home/mseminario2/chips/castalia/ic/.simulation/castalia/tb_anatop_pixel_dacR2R12/maestro/results/maestro/Interactive.34/1/LineRegTB/psf")
  openResults("/home/mseminario2/chips/castalia/ic/.simulation/castalia/tb_anatop_pixel_dacR2R12/maestro/results/maestro/Interactive.34/1/LineRegTB/psf")
  when(member('dc results())
    selectResult('dc)
    mtxP = outfile("/home/mseminario2/vestarv/implementations/asic/castalia/analog/data/raw/dr_line__tt.meta" "w")
    fprintf(mtxP "sweep %%L\n" car(errset(sweepNames())))
    close(mtxP)
    errset(mtxDump("/home/mseminario2/vestarv/implementations/asic/castalia/analog/data/raw/dr_line__tt__dvddac_line.csv" (value(VS("/VddDac") VAR("vdd_hi")) - value(VS("/VddDac") VAR("vdd_lo")))))
    errset(mtxDump("/home/mseminario2/vestarv/implementations/asic/castalia/analog/data/raw/dr_line__tt__i_q.csv" abs(IDC("/POWER/SRC_VDD25/PLUS"))))
    errset(mtxDump("/home/mseminario2/vestarv/implementations/asic/castalia/analog/data/raw/dr_line__tt__line_reg.csv" ((value(VS("/VddDac") VAR("vdd_hi")) - value(VS("/VddDac") VAR("vdd_lo"))) / (VAR("vdd_hi") - VAR("vdd_lo")))))
    errset(mtxDump("/home/mseminario2/vestarv/implementations/asic/castalia/analog/data/raw/dr_line__tt__vddac_ln.csv" VS("/VddDac")))
    errset(mtxDump("/home/mseminario2/vestarv/implementations/asic/castalia/analog/data/raw/dr_line__tt__vddac_nom.csv" value(VS("/VddDac") VAR("VDD25"))))
  )
)

;; ---- corner 1 (tt) / test dr_load
when(isDir("/home/mseminario2/chips/castalia/ic/.simulation/castalia/tb_anatop_pixel_dacR2R12/maestro/results/maestro/Interactive.34/1/LoadRegTB/psf")
  openResults("/home/mseminario2/chips/castalia/ic/.simulation/castalia/tb_anatop_pixel_dacR2R12/maestro/results/maestro/Interactive.34/1/LoadRegTB/psf")
  when(member('dc results())
    selectResult('dc)
    mtxP = outfile("/home/mseminario2/vestarv/implementations/asic/castalia/analog/data/raw/dr_load__tt.meta" "w")
    fprintf(mtxP "sweep %%L\n" car(errset(sweepNames())))
    close(mtxP)
    errset(mtxDump("/home/mseminario2/vestarv/implementations/asic/castalia/analog/data/raw/dr_load__tt__dvddac_load.csv" (value(VS("/VddDac") 0) - value(VS("/VddDac") VAR("i_load_max")))))
    errset(mtxDump("/home/mseminario2/vestarv/implementations/asic/castalia/analog/data/raw/dr_load__tt__load_reg.csv" ((value(VS("/VddDac") 0) - value(VS("/VddDac") VAR("i_load_max"))) / VAR("i_load_max"))))
    errset(mtxDump("/home/mseminario2/vestarv/implementations/asic/castalia/analog/data/raw/dr_load__tt__vddac_full.csv" value(VS("/VddDac") VAR("i_load_max"))))
    errset(mtxDump("/home/mseminario2/vestarv/implementations/asic/castalia/analog/data/raw/dr_load__tt__vddac_l.csv" VS("/VddDac")))
    errset(mtxDump("/home/mseminario2/vestarv/implementations/asic/castalia/analog/data/raw/dr_load__tt__vddac_noload.csv" value(VS("/VddDac") 0)))
  )
)

;; ---- corner 1 (tt) / test dr_startup
when(isDir("/home/mseminario2/chips/castalia/ic/.simulation/castalia/tb_anatop_pixel_dacR2R12/maestro/results/maestro/Interactive.34/1/PSUStartupTB/psf")
  openResults("/home/mseminario2/chips/castalia/ic/.simulation/castalia/tb_anatop_pixel_dacR2R12/maestro/results/maestro/Interactive.34/1/PSUStartupTB/psf")
  when(member('tran results())
    selectResult('tran)
    mtxP = outfile("/home/mseminario2/vestarv/implementations/asic/castalia/analog/data/raw/dr_startup__tt.meta" "w")
    fprintf(mtxP "sweep %%L\n" car(errset(sweepNames())))
    close(mtxP)
    errset(mtxDump("/home/mseminario2/vestarv/implementations/asic/castalia/analog/data/raw/dr_startup__tt__vddac_t.csv" VT("/VddDac")))
  )
)

;; ---- corner 1 (tt) / test dr_wpsu
when(isDir("/home/mseminario2/chips/castalia/ic/.simulation/castalia/tb_anatop_pixel_dacR2R12/maestro/results/maestro/Interactive.34/1/DacNonlinWPSUTB/psf")
  openResults("/home/mseminario2/chips/castalia/ic/.simulation/castalia/tb_anatop_pixel_dacR2R12/maestro/results/maestro/Interactive.34/1/DacNonlinWPSUTB/psf")
  when(member('dc results())
    selectResult('dc)
    mtxP = outfile("/home/mseminario2/vestarv/implementations/asic/castalia/analog/data/raw/dr_wpsu__tt.meta" "w")
    fprintf(mtxP "sweep %%L\n" car(errset(sweepNames())))
    close(mtxP)
    errset(mtxDump("/home/mseminario2/vestarv/implementations/asic/castalia/analog/data/raw/dr_wpsu__tt__code_vdac_min.csv" xmin(VS("/VddDac"))))
    errset(mtxDump("/home/mseminario2/vestarv/implementations/asic/castalia/analog/data/raw/dr_wpsu__tt__dnl_min.csv" ymin(((deriv(VS("/Out")) / ((value(VS("/Out") 4095) - value(VS("/Out") 0)) / 4095)) - 1))))
    errset(mtxDump("/home/mseminario2/vestarv/implementations/asic/castalia/analog/data/raw/dr_wpsu__tt__dnl_n_lsb.csv" ymax(abs(((deriv((VS("/Out") / VS("/VddDac"))) / ((value((VS("/Out") / VS("/VddDac")) 4095) - value((VS("/Out") / VS("/VddDac")) 0)) / 4095)) - 1)))))
    errset(mtxDump("/home/mseminario2/vestarv/implementations/asic/castalia/analog/data/raw/dr_wpsu__tt__dnl_n_min.csv" ymin(((deriv((VS("/Out") / VS("/VddDac"))) / ((value((VS("/Out") / VS("/VddDac")) 4095) - value((VS("/Out") / VS("/VddDac")) 0)) / 4095)) - 1))))
    errset(mtxDump("/home/mseminario2/vestarv/implementations/asic/castalia/analog/data/raw/dr_wpsu__tt__dnl_n_wave.csv" ((deriv((VS("/Out") / VS("/VddDac"))) / ((value((VS("/Out") / VS("/VddDac")) 4095) - value((VS("/Out") / VS("/VddDac")) 0)) / 4095)) - 1)))
    errset(mtxDump("/home/mseminario2/vestarv/implementations/asic/castalia/analog/data/raw/dr_wpsu__tt__gain_err.csv" (((value((VS("/Out") / VS("/VddDac")) 4095) - value((VS("/Out") / VS("/VddDac")) 0)) / (4095.0 / 4096.0)) - 1)))
    errset(mtxDump("/home/mseminario2/vestarv/implementations/asic/castalia/analog/data/raw/dr_wpsu__tt__inl_lsb.csv" ymax(abs(((VS("/Out") - (value(VS("/Out") 0) + (((value(VS("/Out") 4095) - value(VS("/Out") 0)) / 4095) * xval(VS("/Out"))))) / ((value(VS("/Out") 4095) - value(VS("/Out") 0)) / 4095))))))
    errset(mtxDump("/home/mseminario2/vestarv/implementations/asic/castalia/analog/data/raw/dr_wpsu__tt__inl_n_lsb.csv" ymax(abs((((VS("/Out") / VS("/VddDac")) - (value((VS("/Out") / VS("/VddDac")) 0) + (((value((VS("/Out") / VS("/VddDac")) 4095) - value((VS("/Out") / VS("/VddDac")) 0)) / 4095) * xval(VS("/Out"))))) / ((value((VS("/Out") / VS("/VddDac")) 4095) - value((VS("/Out") / VS("/VddDac")) 0)) / 4095))))))
    errset(mtxDump("/home/mseminario2/vestarv/implementations/asic/castalia/analog/data/raw/dr_wpsu__tt__inl_wave.csv" ((VS("/Out") - (value(VS("/Out") 0) + (((value(VS("/Out") 4095) - value(VS("/Out") 0)) / 4095) * xval(VS("/Out"))))) / ((value(VS("/Out") 4095) - value(VS("/Out") 0)) / 4095))))
    errset(mtxDump("/home/mseminario2/vestarv/implementations/asic/castalia/analog/data/raw/dr_wpsu__tt__lsb.csv" ((value(VS("/Out") 4095) - value(VS("/Out") 0)) / 4095)))
    errset(mtxDump("/home/mseminario2/vestarv/implementations/asic/castalia/analog/data/raw/dr_wpsu__tt__v_fs.csv" value(VS("/Out") 4095)))
    errset(mtxDump("/home/mseminario2/vestarv/implementations/asic/castalia/analog/data/raw/dr_wpsu__tt__vddac_dev.csv" (VS("/VddDac") - value(VS("/VddDac") 0))))
    errset(mtxDump("/home/mseminario2/vestarv/implementations/asic/castalia/analog/data/raw/dr_wpsu__tt__vddac_max.csv" ymax(VS("/VddDac"))))
    errset(mtxDump("/home/mseminario2/vestarv/implementations/asic/castalia/analog/data/raw/dr_wpsu__tt__vddac_min.csv" ymin(VS("/VddDac"))))
    errset(mtxDump("/home/mseminario2/vestarv/implementations/asic/castalia/analog/data/raw/dr_wpsu__tt__vddac_pp.csv" (ymax(VS("/VddDac")) - ymin(VS("/VddDac")))))
    errset(mtxDump("/home/mseminario2/vestarv/implementations/asic/castalia/analog/data/raw/dr_wpsu__tt__voff_lsb.csv" (value((VS("/Out") / VS("/VddDac")) 0) / ((value((VS("/Out") / VS("/VddDac")) 4095) - value((VS("/Out") / VS("/VddDac")) 0)) / 4095))))
  )
)

;; ---- corner 1 (tt) / test dr_zout
when(isDir("/home/mseminario2/chips/castalia/ic/.simulation/castalia/tb_anatop_pixel_dacR2R12/maestro/results/maestro/Interactive.34/1/ZoutTB/psf")
  openResults("/home/mseminario2/chips/castalia/ic/.simulation/castalia/tb_anatop_pixel_dacR2R12/maestro/results/maestro/Interactive.34/1/ZoutTB/psf")
  when(member('ac results())
    selectResult('ac)
    mtxP = outfile("/home/mseminario2/vestarv/implementations/asic/castalia/analog/data/raw/dr_zout__tt.meta" "w")
    fprintf(mtxP "sweep %%L\n" car(errset(sweepNames())))
    close(mtxP)
    errset(mtxDump("/home/mseminario2/vestarv/implementations/asic/castalia/analog/data/raw/dr_zout__tt__f_zout_peak.csv" xmax(mag(VF("/VddDac")))))
    errset(mtxDump("/home/mseminario2/vestarv/implementations/asic/castalia/analog/data/raw/dr_zout__tt__zout_100k.csv" value(mag(VF("/VddDac")) 100000)))
    errset(mtxDump("/home/mseminario2/vestarv/implementations/asic/castalia/analog/data/raw/dr_zout__tt__zout_1k.csv" value(mag(VF("/VddDac")) 1000)))
    errset(mtxDump("/home/mseminario2/vestarv/implementations/asic/castalia/analog/data/raw/dr_zout__tt__zout_lf.csv" value(mag(VF("/VddDac")) 1)))
    errset(mtxDump("/home/mseminario2/vestarv/implementations/asic/castalia/analog/data/raw/dr_zout__tt__zout_max.csv" ymax(mag(VF("/VddDac")))))
    errset(mtxDump("/home/mseminario2/vestarv/implementations/asic/castalia/analog/data/raw/dr_zout__tt__zout_wave.csv" mag(VF("/VddDac"))))
  )
)

;; ---- corner 2 (ff) / test dr_ideal
when(isDir("/home/mseminario2/chips/castalia/ic/.simulation/castalia/tb_anatop_pixel_dacR2R12/maestro/results/maestro/Interactive.34/2/DacNonlinTB/psf")
  openResults("/home/mseminario2/chips/castalia/ic/.simulation/castalia/tb_anatop_pixel_dacR2R12/maestro/results/maestro/Interactive.34/2/DacNonlinTB/psf")
  when(member('dc results())
    selectResult('dc)
    mtxP = outfile("/home/mseminario2/vestarv/implementations/asic/castalia/analog/data/raw/dr_ideal__ff.meta" "w")
    fprintf(mtxP "sweep %%L\n" car(errset(sweepNames())))
    close(mtxP)
    errset(mtxDump("/home/mseminario2/vestarv/implementations/asic/castalia/analog/data/raw/dr_ideal__ff__dnl_lsb.csv" ymax(abs(((deriv(VS("/Out")) / ((value(VS("/Out") 4095) - value(VS("/Out") 0)) / 4095)) - 1)))))
    errset(mtxDump("/home/mseminario2/vestarv/implementations/asic/castalia/analog/data/raw/dr_ideal__ff__dnl_max.csv" ymax(((deriv(VS("/Out")) / ((value(VS("/Out") 4095) - value(VS("/Out") 0)) / 4095)) - 1))))
    errset(mtxDump("/home/mseminario2/vestarv/implementations/asic/castalia/analog/data/raw/dr_ideal__ff__dnl_min.csv" ymin(((deriv(VS("/Out")) / ((value(VS("/Out") 4095) - value(VS("/Out") 0)) / 4095)) - 1))))
    errset(mtxDump("/home/mseminario2/vestarv/implementations/asic/castalia/analog/data/raw/dr_ideal__ff__dnl_wave.csv" ((deriv(VS("/Out")) / ((value(VS("/Out") 4095) - value(VS("/Out") 0)) / 4095)) - 1)))
    errset(mtxDump("/home/mseminario2/vestarv/implementations/asic/castalia/analog/data/raw/dr_ideal__ff__inl_lsb.csv" ymax(abs(((VS("/Out") - (value(VS("/Out") 0) + (((value(VS("/Out") 4095) - value(VS("/Out") 0)) / 4095) * xval(VS("/Out"))))) / ((value(VS("/Out") 4095) - value(VS("/Out") 0)) / 4095))))))
    errset(mtxDump("/home/mseminario2/vestarv/implementations/asic/castalia/analog/data/raw/dr_ideal__ff__inl_max.csv" ymax(((VS("/Out") - (value(VS("/Out") 0) + (((value(VS("/Out") 4095) - value(VS("/Out") 0)) / 4095) * xval(VS("/Out"))))) / ((value(VS("/Out") 4095) - value(VS("/Out") 0)) / 4095)))))
    errset(mtxDump("/home/mseminario2/vestarv/implementations/asic/castalia/analog/data/raw/dr_ideal__ff__inl_min.csv" ymin(((VS("/Out") - (value(VS("/Out") 0) + (((value(VS("/Out") 4095) - value(VS("/Out") 0)) / 4095) * xval(VS("/Out"))))) / ((value(VS("/Out") 4095) - value(VS("/Out") 0)) / 4095)))))
    errset(mtxDump("/home/mseminario2/vestarv/implementations/asic/castalia/analog/data/raw/dr_ideal__ff__inl_wave.csv" ((VS("/Out") - (value(VS("/Out") 0) + (((value(VS("/Out") 4095) - value(VS("/Out") 0)) / 4095) * xval(VS("/Out"))))) / ((value(VS("/Out") 4095) - value(VS("/Out") 0)) / 4095))))
    errset(mtxDump("/home/mseminario2/vestarv/implementations/asic/castalia/analog/data/raw/dr_ideal__ff__lsb.csv" ((value(VS("/Out") 4095) - value(VS("/Out") 0)) / 4095)))
    errset(mtxDump("/home/mseminario2/vestarv/implementations/asic/castalia/analog/data/raw/dr_ideal__ff__v_fs.csv" value(VS("/Out") 4095)))
    errset(mtxDump("/home/mseminario2/vestarv/implementations/asic/castalia/analog/data/raw/dr_ideal__ff__v_zs.csv" value(VS("/Out") 0)))
  )
)

;; ---- corner 2 (ff) / test dr_line
when(isDir("/home/mseminario2/chips/castalia/ic/.simulation/castalia/tb_anatop_pixel_dacR2R12/maestro/results/maestro/Interactive.34/2/LineRegTB/psf")
  openResults("/home/mseminario2/chips/castalia/ic/.simulation/castalia/tb_anatop_pixel_dacR2R12/maestro/results/maestro/Interactive.34/2/LineRegTB/psf")
  when(member('dc results())
    selectResult('dc)
    mtxP = outfile("/home/mseminario2/vestarv/implementations/asic/castalia/analog/data/raw/dr_line__ff.meta" "w")
    fprintf(mtxP "sweep %%L\n" car(errset(sweepNames())))
    close(mtxP)
    errset(mtxDump("/home/mseminario2/vestarv/implementations/asic/castalia/analog/data/raw/dr_line__ff__dvddac_line.csv" (value(VS("/VddDac") VAR("vdd_hi")) - value(VS("/VddDac") VAR("vdd_lo")))))
    errset(mtxDump("/home/mseminario2/vestarv/implementations/asic/castalia/analog/data/raw/dr_line__ff__i_q.csv" abs(IDC("/POWER/SRC_VDD25/PLUS"))))
    errset(mtxDump("/home/mseminario2/vestarv/implementations/asic/castalia/analog/data/raw/dr_line__ff__line_reg.csv" ((value(VS("/VddDac") VAR("vdd_hi")) - value(VS("/VddDac") VAR("vdd_lo"))) / (VAR("vdd_hi") - VAR("vdd_lo")))))
    errset(mtxDump("/home/mseminario2/vestarv/implementations/asic/castalia/analog/data/raw/dr_line__ff__vddac_ln.csv" VS("/VddDac")))
    errset(mtxDump("/home/mseminario2/vestarv/implementations/asic/castalia/analog/data/raw/dr_line__ff__vddac_nom.csv" value(VS("/VddDac") VAR("VDD25"))))
  )
)

;; ---- corner 2 (ff) / test dr_load
when(isDir("/home/mseminario2/chips/castalia/ic/.simulation/castalia/tb_anatop_pixel_dacR2R12/maestro/results/maestro/Interactive.34/2/LoadRegTB/psf")
  openResults("/home/mseminario2/chips/castalia/ic/.simulation/castalia/tb_anatop_pixel_dacR2R12/maestro/results/maestro/Interactive.34/2/LoadRegTB/psf")
  when(member('dc results())
    selectResult('dc)
    mtxP = outfile("/home/mseminario2/vestarv/implementations/asic/castalia/analog/data/raw/dr_load__ff.meta" "w")
    fprintf(mtxP "sweep %%L\n" car(errset(sweepNames())))
    close(mtxP)
    errset(mtxDump("/home/mseminario2/vestarv/implementations/asic/castalia/analog/data/raw/dr_load__ff__dvddac_load.csv" (value(VS("/VddDac") 0) - value(VS("/VddDac") VAR("i_load_max")))))
    errset(mtxDump("/home/mseminario2/vestarv/implementations/asic/castalia/analog/data/raw/dr_load__ff__load_reg.csv" ((value(VS("/VddDac") 0) - value(VS("/VddDac") VAR("i_load_max"))) / VAR("i_load_max"))))
    errset(mtxDump("/home/mseminario2/vestarv/implementations/asic/castalia/analog/data/raw/dr_load__ff__vddac_full.csv" value(VS("/VddDac") VAR("i_load_max"))))
    errset(mtxDump("/home/mseminario2/vestarv/implementations/asic/castalia/analog/data/raw/dr_load__ff__vddac_l.csv" VS("/VddDac")))
    errset(mtxDump("/home/mseminario2/vestarv/implementations/asic/castalia/analog/data/raw/dr_load__ff__vddac_noload.csv" value(VS("/VddDac") 0)))
  )
)

;; ---- corner 2 (ff) / test dr_startup
when(isDir("/home/mseminario2/chips/castalia/ic/.simulation/castalia/tb_anatop_pixel_dacR2R12/maestro/results/maestro/Interactive.34/2/PSUStartupTB/psf")
  openResults("/home/mseminario2/chips/castalia/ic/.simulation/castalia/tb_anatop_pixel_dacR2R12/maestro/results/maestro/Interactive.34/2/PSUStartupTB/psf")
  when(member('tran results())
    selectResult('tran)
    mtxP = outfile("/home/mseminario2/vestarv/implementations/asic/castalia/analog/data/raw/dr_startup__ff.meta" "w")
    fprintf(mtxP "sweep %%L\n" car(errset(sweepNames())))
    close(mtxP)
    errset(mtxDump("/home/mseminario2/vestarv/implementations/asic/castalia/analog/data/raw/dr_startup__ff__vddac_t.csv" VT("/VddDac")))
  )
)

;; ---- corner 2 (ff) / test dr_wpsu
when(isDir("/home/mseminario2/chips/castalia/ic/.simulation/castalia/tb_anatop_pixel_dacR2R12/maestro/results/maestro/Interactive.34/2/DacNonlinWPSUTB/psf")
  openResults("/home/mseminario2/chips/castalia/ic/.simulation/castalia/tb_anatop_pixel_dacR2R12/maestro/results/maestro/Interactive.34/2/DacNonlinWPSUTB/psf")
  when(member('dc results())
    selectResult('dc)
    mtxP = outfile("/home/mseminario2/vestarv/implementations/asic/castalia/analog/data/raw/dr_wpsu__ff.meta" "w")
    fprintf(mtxP "sweep %%L\n" car(errset(sweepNames())))
    close(mtxP)
    errset(mtxDump("/home/mseminario2/vestarv/implementations/asic/castalia/analog/data/raw/dr_wpsu__ff__code_vdac_min.csv" xmin(VS("/VddDac"))))
    errset(mtxDump("/home/mseminario2/vestarv/implementations/asic/castalia/analog/data/raw/dr_wpsu__ff__dnl_min.csv" ymin(((deriv(VS("/Out")) / ((value(VS("/Out") 4095) - value(VS("/Out") 0)) / 4095)) - 1))))
    errset(mtxDump("/home/mseminario2/vestarv/implementations/asic/castalia/analog/data/raw/dr_wpsu__ff__dnl_n_lsb.csv" ymax(abs(((deriv((VS("/Out") / VS("/VddDac"))) / ((value((VS("/Out") / VS("/VddDac")) 4095) - value((VS("/Out") / VS("/VddDac")) 0)) / 4095)) - 1)))))
    errset(mtxDump("/home/mseminario2/vestarv/implementations/asic/castalia/analog/data/raw/dr_wpsu__ff__dnl_n_min.csv" ymin(((deriv((VS("/Out") / VS("/VddDac"))) / ((value((VS("/Out") / VS("/VddDac")) 4095) - value((VS("/Out") / VS("/VddDac")) 0)) / 4095)) - 1))))
    errset(mtxDump("/home/mseminario2/vestarv/implementations/asic/castalia/analog/data/raw/dr_wpsu__ff__dnl_n_wave.csv" ((deriv((VS("/Out") / VS("/VddDac"))) / ((value((VS("/Out") / VS("/VddDac")) 4095) - value((VS("/Out") / VS("/VddDac")) 0)) / 4095)) - 1)))
    errset(mtxDump("/home/mseminario2/vestarv/implementations/asic/castalia/analog/data/raw/dr_wpsu__ff__gain_err.csv" (((value((VS("/Out") / VS("/VddDac")) 4095) - value((VS("/Out") / VS("/VddDac")) 0)) / (4095.0 / 4096.0)) - 1)))
    errset(mtxDump("/home/mseminario2/vestarv/implementations/asic/castalia/analog/data/raw/dr_wpsu__ff__inl_lsb.csv" ymax(abs(((VS("/Out") - (value(VS("/Out") 0) + (((value(VS("/Out") 4095) - value(VS("/Out") 0)) / 4095) * xval(VS("/Out"))))) / ((value(VS("/Out") 4095) - value(VS("/Out") 0)) / 4095))))))
    errset(mtxDump("/home/mseminario2/vestarv/implementations/asic/castalia/analog/data/raw/dr_wpsu__ff__inl_n_lsb.csv" ymax(abs((((VS("/Out") / VS("/VddDac")) - (value((VS("/Out") / VS("/VddDac")) 0) + (((value((VS("/Out") / VS("/VddDac")) 4095) - value((VS("/Out") / VS("/VddDac")) 0)) / 4095) * xval(VS("/Out"))))) / ((value((VS("/Out") / VS("/VddDac")) 4095) - value((VS("/Out") / VS("/VddDac")) 0)) / 4095))))))
    errset(mtxDump("/home/mseminario2/vestarv/implementations/asic/castalia/analog/data/raw/dr_wpsu__ff__inl_wave.csv" ((VS("/Out") - (value(VS("/Out") 0) + (((value(VS("/Out") 4095) - value(VS("/Out") 0)) / 4095) * xval(VS("/Out"))))) / ((value(VS("/Out") 4095) - value(VS("/Out") 0)) / 4095))))
    errset(mtxDump("/home/mseminario2/vestarv/implementations/asic/castalia/analog/data/raw/dr_wpsu__ff__lsb.csv" ((value(VS("/Out") 4095) - value(VS("/Out") 0)) / 4095)))
    errset(mtxDump("/home/mseminario2/vestarv/implementations/asic/castalia/analog/data/raw/dr_wpsu__ff__v_fs.csv" value(VS("/Out") 4095)))
    errset(mtxDump("/home/mseminario2/vestarv/implementations/asic/castalia/analog/data/raw/dr_wpsu__ff__vddac_dev.csv" (VS("/VddDac") - value(VS("/VddDac") 0))))
    errset(mtxDump("/home/mseminario2/vestarv/implementations/asic/castalia/analog/data/raw/dr_wpsu__ff__vddac_max.csv" ymax(VS("/VddDac"))))
    errset(mtxDump("/home/mseminario2/vestarv/implementations/asic/castalia/analog/data/raw/dr_wpsu__ff__vddac_min.csv" ymin(VS("/VddDac"))))
    errset(mtxDump("/home/mseminario2/vestarv/implementations/asic/castalia/analog/data/raw/dr_wpsu__ff__vddac_pp.csv" (ymax(VS("/VddDac")) - ymin(VS("/VddDac")))))
    errset(mtxDump("/home/mseminario2/vestarv/implementations/asic/castalia/analog/data/raw/dr_wpsu__ff__voff_lsb.csv" (value((VS("/Out") / VS("/VddDac")) 0) / ((value((VS("/Out") / VS("/VddDac")) 4095) - value((VS("/Out") / VS("/VddDac")) 0)) / 4095))))
  )
)

;; ---- corner 2 (ff) / test dr_zout
when(isDir("/home/mseminario2/chips/castalia/ic/.simulation/castalia/tb_anatop_pixel_dacR2R12/maestro/results/maestro/Interactive.34/2/ZoutTB/psf")
  openResults("/home/mseminario2/chips/castalia/ic/.simulation/castalia/tb_anatop_pixel_dacR2R12/maestro/results/maestro/Interactive.34/2/ZoutTB/psf")
  when(member('ac results())
    selectResult('ac)
    mtxP = outfile("/home/mseminario2/vestarv/implementations/asic/castalia/analog/data/raw/dr_zout__ff.meta" "w")
    fprintf(mtxP "sweep %%L\n" car(errset(sweepNames())))
    close(mtxP)
    errset(mtxDump("/home/mseminario2/vestarv/implementations/asic/castalia/analog/data/raw/dr_zout__ff__f_zout_peak.csv" xmax(mag(VF("/VddDac")))))
    errset(mtxDump("/home/mseminario2/vestarv/implementations/asic/castalia/analog/data/raw/dr_zout__ff__zout_100k.csv" value(mag(VF("/VddDac")) 100000)))
    errset(mtxDump("/home/mseminario2/vestarv/implementations/asic/castalia/analog/data/raw/dr_zout__ff__zout_1k.csv" value(mag(VF("/VddDac")) 1000)))
    errset(mtxDump("/home/mseminario2/vestarv/implementations/asic/castalia/analog/data/raw/dr_zout__ff__zout_lf.csv" value(mag(VF("/VddDac")) 1)))
    errset(mtxDump("/home/mseminario2/vestarv/implementations/asic/castalia/analog/data/raw/dr_zout__ff__zout_max.csv" ymax(mag(VF("/VddDac")))))
    errset(mtxDump("/home/mseminario2/vestarv/implementations/asic/castalia/analog/data/raw/dr_zout__ff__zout_wave.csv" mag(VF("/VddDac"))))
  )
)

;; ---- corner 3 (fs) / test dr_ideal
when(isDir("/home/mseminario2/chips/castalia/ic/.simulation/castalia/tb_anatop_pixel_dacR2R12/maestro/results/maestro/Interactive.34/3/DacNonlinTB/psf")
  openResults("/home/mseminario2/chips/castalia/ic/.simulation/castalia/tb_anatop_pixel_dacR2R12/maestro/results/maestro/Interactive.34/3/DacNonlinTB/psf")
  when(member('dc results())
    selectResult('dc)
    mtxP = outfile("/home/mseminario2/vestarv/implementations/asic/castalia/analog/data/raw/dr_ideal__fs.meta" "w")
    fprintf(mtxP "sweep %%L\n" car(errset(sweepNames())))
    close(mtxP)
    errset(mtxDump("/home/mseminario2/vestarv/implementations/asic/castalia/analog/data/raw/dr_ideal__fs__dnl_lsb.csv" ymax(abs(((deriv(VS("/Out")) / ((value(VS("/Out") 4095) - value(VS("/Out") 0)) / 4095)) - 1)))))
    errset(mtxDump("/home/mseminario2/vestarv/implementations/asic/castalia/analog/data/raw/dr_ideal__fs__dnl_max.csv" ymax(((deriv(VS("/Out")) / ((value(VS("/Out") 4095) - value(VS("/Out") 0)) / 4095)) - 1))))
    errset(mtxDump("/home/mseminario2/vestarv/implementations/asic/castalia/analog/data/raw/dr_ideal__fs__dnl_min.csv" ymin(((deriv(VS("/Out")) / ((value(VS("/Out") 4095) - value(VS("/Out") 0)) / 4095)) - 1))))
    errset(mtxDump("/home/mseminario2/vestarv/implementations/asic/castalia/analog/data/raw/dr_ideal__fs__dnl_wave.csv" ((deriv(VS("/Out")) / ((value(VS("/Out") 4095) - value(VS("/Out") 0)) / 4095)) - 1)))
    errset(mtxDump("/home/mseminario2/vestarv/implementations/asic/castalia/analog/data/raw/dr_ideal__fs__inl_lsb.csv" ymax(abs(((VS("/Out") - (value(VS("/Out") 0) + (((value(VS("/Out") 4095) - value(VS("/Out") 0)) / 4095) * xval(VS("/Out"))))) / ((value(VS("/Out") 4095) - value(VS("/Out") 0)) / 4095))))))
    errset(mtxDump("/home/mseminario2/vestarv/implementations/asic/castalia/analog/data/raw/dr_ideal__fs__inl_max.csv" ymax(((VS("/Out") - (value(VS("/Out") 0) + (((value(VS("/Out") 4095) - value(VS("/Out") 0)) / 4095) * xval(VS("/Out"))))) / ((value(VS("/Out") 4095) - value(VS("/Out") 0)) / 4095)))))
    errset(mtxDump("/home/mseminario2/vestarv/implementations/asic/castalia/analog/data/raw/dr_ideal__fs__inl_min.csv" ymin(((VS("/Out") - (value(VS("/Out") 0) + (((value(VS("/Out") 4095) - value(VS("/Out") 0)) / 4095) * xval(VS("/Out"))))) / ((value(VS("/Out") 4095) - value(VS("/Out") 0)) / 4095)))))
    errset(mtxDump("/home/mseminario2/vestarv/implementations/asic/castalia/analog/data/raw/dr_ideal__fs__inl_wave.csv" ((VS("/Out") - (value(VS("/Out") 0) + (((value(VS("/Out") 4095) - value(VS("/Out") 0)) / 4095) * xval(VS("/Out"))))) / ((value(VS("/Out") 4095) - value(VS("/Out") 0)) / 4095))))
    errset(mtxDump("/home/mseminario2/vestarv/implementations/asic/castalia/analog/data/raw/dr_ideal__fs__lsb.csv" ((value(VS("/Out") 4095) - value(VS("/Out") 0)) / 4095)))
    errset(mtxDump("/home/mseminario2/vestarv/implementations/asic/castalia/analog/data/raw/dr_ideal__fs__v_fs.csv" value(VS("/Out") 4095)))
    errset(mtxDump("/home/mseminario2/vestarv/implementations/asic/castalia/analog/data/raw/dr_ideal__fs__v_zs.csv" value(VS("/Out") 0)))
  )
)

;; ---- corner 3 (fs) / test dr_line
when(isDir("/home/mseminario2/chips/castalia/ic/.simulation/castalia/tb_anatop_pixel_dacR2R12/maestro/results/maestro/Interactive.34/3/LineRegTB/psf")
  openResults("/home/mseminario2/chips/castalia/ic/.simulation/castalia/tb_anatop_pixel_dacR2R12/maestro/results/maestro/Interactive.34/3/LineRegTB/psf")
  when(member('dc results())
    selectResult('dc)
    mtxP = outfile("/home/mseminario2/vestarv/implementations/asic/castalia/analog/data/raw/dr_line__fs.meta" "w")
    fprintf(mtxP "sweep %%L\n" car(errset(sweepNames())))
    close(mtxP)
    errset(mtxDump("/home/mseminario2/vestarv/implementations/asic/castalia/analog/data/raw/dr_line__fs__dvddac_line.csv" (value(VS("/VddDac") VAR("vdd_hi")) - value(VS("/VddDac") VAR("vdd_lo")))))
    errset(mtxDump("/home/mseminario2/vestarv/implementations/asic/castalia/analog/data/raw/dr_line__fs__i_q.csv" abs(IDC("/POWER/SRC_VDD25/PLUS"))))
    errset(mtxDump("/home/mseminario2/vestarv/implementations/asic/castalia/analog/data/raw/dr_line__fs__line_reg.csv" ((value(VS("/VddDac") VAR("vdd_hi")) - value(VS("/VddDac") VAR("vdd_lo"))) / (VAR("vdd_hi") - VAR("vdd_lo")))))
    errset(mtxDump("/home/mseminario2/vestarv/implementations/asic/castalia/analog/data/raw/dr_line__fs__vddac_ln.csv" VS("/VddDac")))
    errset(mtxDump("/home/mseminario2/vestarv/implementations/asic/castalia/analog/data/raw/dr_line__fs__vddac_nom.csv" value(VS("/VddDac") VAR("VDD25"))))
  )
)

;; ---- corner 3 (fs) / test dr_load
when(isDir("/home/mseminario2/chips/castalia/ic/.simulation/castalia/tb_anatop_pixel_dacR2R12/maestro/results/maestro/Interactive.34/3/LoadRegTB/psf")
  openResults("/home/mseminario2/chips/castalia/ic/.simulation/castalia/tb_anatop_pixel_dacR2R12/maestro/results/maestro/Interactive.34/3/LoadRegTB/psf")
  when(member('dc results())
    selectResult('dc)
    mtxP = outfile("/home/mseminario2/vestarv/implementations/asic/castalia/analog/data/raw/dr_load__fs.meta" "w")
    fprintf(mtxP "sweep %%L\n" car(errset(sweepNames())))
    close(mtxP)
    errset(mtxDump("/home/mseminario2/vestarv/implementations/asic/castalia/analog/data/raw/dr_load__fs__dvddac_load.csv" (value(VS("/VddDac") 0) - value(VS("/VddDac") VAR("i_load_max")))))
    errset(mtxDump("/home/mseminario2/vestarv/implementations/asic/castalia/analog/data/raw/dr_load__fs__load_reg.csv" ((value(VS("/VddDac") 0) - value(VS("/VddDac") VAR("i_load_max"))) / VAR("i_load_max"))))
    errset(mtxDump("/home/mseminario2/vestarv/implementations/asic/castalia/analog/data/raw/dr_load__fs__vddac_full.csv" value(VS("/VddDac") VAR("i_load_max"))))
    errset(mtxDump("/home/mseminario2/vestarv/implementations/asic/castalia/analog/data/raw/dr_load__fs__vddac_l.csv" VS("/VddDac")))
    errset(mtxDump("/home/mseminario2/vestarv/implementations/asic/castalia/analog/data/raw/dr_load__fs__vddac_noload.csv" value(VS("/VddDac") 0)))
  )
)

;; ---- corner 3 (fs) / test dr_startup
when(isDir("/home/mseminario2/chips/castalia/ic/.simulation/castalia/tb_anatop_pixel_dacR2R12/maestro/results/maestro/Interactive.34/3/PSUStartupTB/psf")
  openResults("/home/mseminario2/chips/castalia/ic/.simulation/castalia/tb_anatop_pixel_dacR2R12/maestro/results/maestro/Interactive.34/3/PSUStartupTB/psf")
  when(member('tran results())
    selectResult('tran)
    mtxP = outfile("/home/mseminario2/vestarv/implementations/asic/castalia/analog/data/raw/dr_startup__fs.meta" "w")
    fprintf(mtxP "sweep %%L\n" car(errset(sweepNames())))
    close(mtxP)
    errset(mtxDump("/home/mseminario2/vestarv/implementations/asic/castalia/analog/data/raw/dr_startup__fs__vddac_t.csv" VT("/VddDac")))
  )
)

;; ---- corner 3 (fs) / test dr_wpsu
when(isDir("/home/mseminario2/chips/castalia/ic/.simulation/castalia/tb_anatop_pixel_dacR2R12/maestro/results/maestro/Interactive.34/3/DacNonlinWPSUTB/psf")
  openResults("/home/mseminario2/chips/castalia/ic/.simulation/castalia/tb_anatop_pixel_dacR2R12/maestro/results/maestro/Interactive.34/3/DacNonlinWPSUTB/psf")
  when(member('dc results())
    selectResult('dc)
    mtxP = outfile("/home/mseminario2/vestarv/implementations/asic/castalia/analog/data/raw/dr_wpsu__fs.meta" "w")
    fprintf(mtxP "sweep %%L\n" car(errset(sweepNames())))
    close(mtxP)
    errset(mtxDump("/home/mseminario2/vestarv/implementations/asic/castalia/analog/data/raw/dr_wpsu__fs__code_vdac_min.csv" xmin(VS("/VddDac"))))
    errset(mtxDump("/home/mseminario2/vestarv/implementations/asic/castalia/analog/data/raw/dr_wpsu__fs__dnl_min.csv" ymin(((deriv(VS("/Out")) / ((value(VS("/Out") 4095) - value(VS("/Out") 0)) / 4095)) - 1))))
    errset(mtxDump("/home/mseminario2/vestarv/implementations/asic/castalia/analog/data/raw/dr_wpsu__fs__dnl_n_lsb.csv" ymax(abs(((deriv((VS("/Out") / VS("/VddDac"))) / ((value((VS("/Out") / VS("/VddDac")) 4095) - value((VS("/Out") / VS("/VddDac")) 0)) / 4095)) - 1)))))
    errset(mtxDump("/home/mseminario2/vestarv/implementations/asic/castalia/analog/data/raw/dr_wpsu__fs__dnl_n_min.csv" ymin(((deriv((VS("/Out") / VS("/VddDac"))) / ((value((VS("/Out") / VS("/VddDac")) 4095) - value((VS("/Out") / VS("/VddDac")) 0)) / 4095)) - 1))))
    errset(mtxDump("/home/mseminario2/vestarv/implementations/asic/castalia/analog/data/raw/dr_wpsu__fs__dnl_n_wave.csv" ((deriv((VS("/Out") / VS("/VddDac"))) / ((value((VS("/Out") / VS("/VddDac")) 4095) - value((VS("/Out") / VS("/VddDac")) 0)) / 4095)) - 1)))
    errset(mtxDump("/home/mseminario2/vestarv/implementations/asic/castalia/analog/data/raw/dr_wpsu__fs__gain_err.csv" (((value((VS("/Out") / VS("/VddDac")) 4095) - value((VS("/Out") / VS("/VddDac")) 0)) / (4095.0 / 4096.0)) - 1)))
    errset(mtxDump("/home/mseminario2/vestarv/implementations/asic/castalia/analog/data/raw/dr_wpsu__fs__inl_lsb.csv" ymax(abs(((VS("/Out") - (value(VS("/Out") 0) + (((value(VS("/Out") 4095) - value(VS("/Out") 0)) / 4095) * xval(VS("/Out"))))) / ((value(VS("/Out") 4095) - value(VS("/Out") 0)) / 4095))))))
    errset(mtxDump("/home/mseminario2/vestarv/implementations/asic/castalia/analog/data/raw/dr_wpsu__fs__inl_n_lsb.csv" ymax(abs((((VS("/Out") / VS("/VddDac")) - (value((VS("/Out") / VS("/VddDac")) 0) + (((value((VS("/Out") / VS("/VddDac")) 4095) - value((VS("/Out") / VS("/VddDac")) 0)) / 4095) * xval(VS("/Out"))))) / ((value((VS("/Out") / VS("/VddDac")) 4095) - value((VS("/Out") / VS("/VddDac")) 0)) / 4095))))))
    errset(mtxDump("/home/mseminario2/vestarv/implementations/asic/castalia/analog/data/raw/dr_wpsu__fs__inl_wave.csv" ((VS("/Out") - (value(VS("/Out") 0) + (((value(VS("/Out") 4095) - value(VS("/Out") 0)) / 4095) * xval(VS("/Out"))))) / ((value(VS("/Out") 4095) - value(VS("/Out") 0)) / 4095))))
    errset(mtxDump("/home/mseminario2/vestarv/implementations/asic/castalia/analog/data/raw/dr_wpsu__fs__lsb.csv" ((value(VS("/Out") 4095) - value(VS("/Out") 0)) / 4095)))
    errset(mtxDump("/home/mseminario2/vestarv/implementations/asic/castalia/analog/data/raw/dr_wpsu__fs__v_fs.csv" value(VS("/Out") 4095)))
    errset(mtxDump("/home/mseminario2/vestarv/implementations/asic/castalia/analog/data/raw/dr_wpsu__fs__vddac_dev.csv" (VS("/VddDac") - value(VS("/VddDac") 0))))
    errset(mtxDump("/home/mseminario2/vestarv/implementations/asic/castalia/analog/data/raw/dr_wpsu__fs__vddac_max.csv" ymax(VS("/VddDac"))))
    errset(mtxDump("/home/mseminario2/vestarv/implementations/asic/castalia/analog/data/raw/dr_wpsu__fs__vddac_min.csv" ymin(VS("/VddDac"))))
    errset(mtxDump("/home/mseminario2/vestarv/implementations/asic/castalia/analog/data/raw/dr_wpsu__fs__vddac_pp.csv" (ymax(VS("/VddDac")) - ymin(VS("/VddDac")))))
    errset(mtxDump("/home/mseminario2/vestarv/implementations/asic/castalia/analog/data/raw/dr_wpsu__fs__voff_lsb.csv" (value((VS("/Out") / VS("/VddDac")) 0) / ((value((VS("/Out") / VS("/VddDac")) 4095) - value((VS("/Out") / VS("/VddDac")) 0)) / 4095))))
  )
)

;; ---- corner 3 (fs) / test dr_zout
when(isDir("/home/mseminario2/chips/castalia/ic/.simulation/castalia/tb_anatop_pixel_dacR2R12/maestro/results/maestro/Interactive.34/3/ZoutTB/psf")
  openResults("/home/mseminario2/chips/castalia/ic/.simulation/castalia/tb_anatop_pixel_dacR2R12/maestro/results/maestro/Interactive.34/3/ZoutTB/psf")
  when(member('ac results())
    selectResult('ac)
    mtxP = outfile("/home/mseminario2/vestarv/implementations/asic/castalia/analog/data/raw/dr_zout__fs.meta" "w")
    fprintf(mtxP "sweep %%L\n" car(errset(sweepNames())))
    close(mtxP)
    errset(mtxDump("/home/mseminario2/vestarv/implementations/asic/castalia/analog/data/raw/dr_zout__fs__f_zout_peak.csv" xmax(mag(VF("/VddDac")))))
    errset(mtxDump("/home/mseminario2/vestarv/implementations/asic/castalia/analog/data/raw/dr_zout__fs__zout_100k.csv" value(mag(VF("/VddDac")) 100000)))
    errset(mtxDump("/home/mseminario2/vestarv/implementations/asic/castalia/analog/data/raw/dr_zout__fs__zout_1k.csv" value(mag(VF("/VddDac")) 1000)))
    errset(mtxDump("/home/mseminario2/vestarv/implementations/asic/castalia/analog/data/raw/dr_zout__fs__zout_lf.csv" value(mag(VF("/VddDac")) 1)))
    errset(mtxDump("/home/mseminario2/vestarv/implementations/asic/castalia/analog/data/raw/dr_zout__fs__zout_max.csv" ymax(mag(VF("/VddDac")))))
    errset(mtxDump("/home/mseminario2/vestarv/implementations/asic/castalia/analog/data/raw/dr_zout__fs__zout_wave.csv" mag(VF("/VddDac"))))
  )
)

;; ---- corner 4 (sf) / test dr_ideal
when(isDir("/home/mseminario2/chips/castalia/ic/.simulation/castalia/tb_anatop_pixel_dacR2R12/maestro/results/maestro/Interactive.34/4/DacNonlinTB/psf")
  openResults("/home/mseminario2/chips/castalia/ic/.simulation/castalia/tb_anatop_pixel_dacR2R12/maestro/results/maestro/Interactive.34/4/DacNonlinTB/psf")
  when(member('dc results())
    selectResult('dc)
    mtxP = outfile("/home/mseminario2/vestarv/implementations/asic/castalia/analog/data/raw/dr_ideal__sf.meta" "w")
    fprintf(mtxP "sweep %%L\n" car(errset(sweepNames())))
    close(mtxP)
    errset(mtxDump("/home/mseminario2/vestarv/implementations/asic/castalia/analog/data/raw/dr_ideal__sf__dnl_lsb.csv" ymax(abs(((deriv(VS("/Out")) / ((value(VS("/Out") 4095) - value(VS("/Out") 0)) / 4095)) - 1)))))
    errset(mtxDump("/home/mseminario2/vestarv/implementations/asic/castalia/analog/data/raw/dr_ideal__sf__dnl_max.csv" ymax(((deriv(VS("/Out")) / ((value(VS("/Out") 4095) - value(VS("/Out") 0)) / 4095)) - 1))))
    errset(mtxDump("/home/mseminario2/vestarv/implementations/asic/castalia/analog/data/raw/dr_ideal__sf__dnl_min.csv" ymin(((deriv(VS("/Out")) / ((value(VS("/Out") 4095) - value(VS("/Out") 0)) / 4095)) - 1))))
    errset(mtxDump("/home/mseminario2/vestarv/implementations/asic/castalia/analog/data/raw/dr_ideal__sf__dnl_wave.csv" ((deriv(VS("/Out")) / ((value(VS("/Out") 4095) - value(VS("/Out") 0)) / 4095)) - 1)))
    errset(mtxDump("/home/mseminario2/vestarv/implementations/asic/castalia/analog/data/raw/dr_ideal__sf__inl_lsb.csv" ymax(abs(((VS("/Out") - (value(VS("/Out") 0) + (((value(VS("/Out") 4095) - value(VS("/Out") 0)) / 4095) * xval(VS("/Out"))))) / ((value(VS("/Out") 4095) - value(VS("/Out") 0)) / 4095))))))
    errset(mtxDump("/home/mseminario2/vestarv/implementations/asic/castalia/analog/data/raw/dr_ideal__sf__inl_max.csv" ymax(((VS("/Out") - (value(VS("/Out") 0) + (((value(VS("/Out") 4095) - value(VS("/Out") 0)) / 4095) * xval(VS("/Out"))))) / ((value(VS("/Out") 4095) - value(VS("/Out") 0)) / 4095)))))
    errset(mtxDump("/home/mseminario2/vestarv/implementations/asic/castalia/analog/data/raw/dr_ideal__sf__inl_min.csv" ymin(((VS("/Out") - (value(VS("/Out") 0) + (((value(VS("/Out") 4095) - value(VS("/Out") 0)) / 4095) * xval(VS("/Out"))))) / ((value(VS("/Out") 4095) - value(VS("/Out") 0)) / 4095)))))
    errset(mtxDump("/home/mseminario2/vestarv/implementations/asic/castalia/analog/data/raw/dr_ideal__sf__inl_wave.csv" ((VS("/Out") - (value(VS("/Out") 0) + (((value(VS("/Out") 4095) - value(VS("/Out") 0)) / 4095) * xval(VS("/Out"))))) / ((value(VS("/Out") 4095) - value(VS("/Out") 0)) / 4095))))
    errset(mtxDump("/home/mseminario2/vestarv/implementations/asic/castalia/analog/data/raw/dr_ideal__sf__lsb.csv" ((value(VS("/Out") 4095) - value(VS("/Out") 0)) / 4095)))
    errset(mtxDump("/home/mseminario2/vestarv/implementations/asic/castalia/analog/data/raw/dr_ideal__sf__v_fs.csv" value(VS("/Out") 4095)))
    errset(mtxDump("/home/mseminario2/vestarv/implementations/asic/castalia/analog/data/raw/dr_ideal__sf__v_zs.csv" value(VS("/Out") 0)))
  )
)

;; ---- corner 4 (sf) / test dr_line
when(isDir("/home/mseminario2/chips/castalia/ic/.simulation/castalia/tb_anatop_pixel_dacR2R12/maestro/results/maestro/Interactive.34/4/LineRegTB/psf")
  openResults("/home/mseminario2/chips/castalia/ic/.simulation/castalia/tb_anatop_pixel_dacR2R12/maestro/results/maestro/Interactive.34/4/LineRegTB/psf")
  when(member('dc results())
    selectResult('dc)
    mtxP = outfile("/home/mseminario2/vestarv/implementations/asic/castalia/analog/data/raw/dr_line__sf.meta" "w")
    fprintf(mtxP "sweep %%L\n" car(errset(sweepNames())))
    close(mtxP)
    errset(mtxDump("/home/mseminario2/vestarv/implementations/asic/castalia/analog/data/raw/dr_line__sf__dvddac_line.csv" (value(VS("/VddDac") VAR("vdd_hi")) - value(VS("/VddDac") VAR("vdd_lo")))))
    errset(mtxDump("/home/mseminario2/vestarv/implementations/asic/castalia/analog/data/raw/dr_line__sf__i_q.csv" abs(IDC("/POWER/SRC_VDD25/PLUS"))))
    errset(mtxDump("/home/mseminario2/vestarv/implementations/asic/castalia/analog/data/raw/dr_line__sf__line_reg.csv" ((value(VS("/VddDac") VAR("vdd_hi")) - value(VS("/VddDac") VAR("vdd_lo"))) / (VAR("vdd_hi") - VAR("vdd_lo")))))
    errset(mtxDump("/home/mseminario2/vestarv/implementations/asic/castalia/analog/data/raw/dr_line__sf__vddac_ln.csv" VS("/VddDac")))
    errset(mtxDump("/home/mseminario2/vestarv/implementations/asic/castalia/analog/data/raw/dr_line__sf__vddac_nom.csv" value(VS("/VddDac") VAR("VDD25"))))
  )
)

;; ---- corner 4 (sf) / test dr_load
when(isDir("/home/mseminario2/chips/castalia/ic/.simulation/castalia/tb_anatop_pixel_dacR2R12/maestro/results/maestro/Interactive.34/4/LoadRegTB/psf")
  openResults("/home/mseminario2/chips/castalia/ic/.simulation/castalia/tb_anatop_pixel_dacR2R12/maestro/results/maestro/Interactive.34/4/LoadRegTB/psf")
  when(member('dc results())
    selectResult('dc)
    mtxP = outfile("/home/mseminario2/vestarv/implementations/asic/castalia/analog/data/raw/dr_load__sf.meta" "w")
    fprintf(mtxP "sweep %%L\n" car(errset(sweepNames())))
    close(mtxP)
    errset(mtxDump("/home/mseminario2/vestarv/implementations/asic/castalia/analog/data/raw/dr_load__sf__dvddac_load.csv" (value(VS("/VddDac") 0) - value(VS("/VddDac") VAR("i_load_max")))))
    errset(mtxDump("/home/mseminario2/vestarv/implementations/asic/castalia/analog/data/raw/dr_load__sf__load_reg.csv" ((value(VS("/VddDac") 0) - value(VS("/VddDac") VAR("i_load_max"))) / VAR("i_load_max"))))
    errset(mtxDump("/home/mseminario2/vestarv/implementations/asic/castalia/analog/data/raw/dr_load__sf__vddac_full.csv" value(VS("/VddDac") VAR("i_load_max"))))
    errset(mtxDump("/home/mseminario2/vestarv/implementations/asic/castalia/analog/data/raw/dr_load__sf__vddac_l.csv" VS("/VddDac")))
    errset(mtxDump("/home/mseminario2/vestarv/implementations/asic/castalia/analog/data/raw/dr_load__sf__vddac_noload.csv" value(VS("/VddDac") 0)))
  )
)

;; ---- corner 4 (sf) / test dr_startup
when(isDir("/home/mseminario2/chips/castalia/ic/.simulation/castalia/tb_anatop_pixel_dacR2R12/maestro/results/maestro/Interactive.34/4/PSUStartupTB/psf")
  openResults("/home/mseminario2/chips/castalia/ic/.simulation/castalia/tb_anatop_pixel_dacR2R12/maestro/results/maestro/Interactive.34/4/PSUStartupTB/psf")
  when(member('tran results())
    selectResult('tran)
    mtxP = outfile("/home/mseminario2/vestarv/implementations/asic/castalia/analog/data/raw/dr_startup__sf.meta" "w")
    fprintf(mtxP "sweep %%L\n" car(errset(sweepNames())))
    close(mtxP)
    errset(mtxDump("/home/mseminario2/vestarv/implementations/asic/castalia/analog/data/raw/dr_startup__sf__vddac_t.csv" VT("/VddDac")))
  )
)

;; ---- corner 4 (sf) / test dr_wpsu
when(isDir("/home/mseminario2/chips/castalia/ic/.simulation/castalia/tb_anatop_pixel_dacR2R12/maestro/results/maestro/Interactive.34/4/DacNonlinWPSUTB/psf")
  openResults("/home/mseminario2/chips/castalia/ic/.simulation/castalia/tb_anatop_pixel_dacR2R12/maestro/results/maestro/Interactive.34/4/DacNonlinWPSUTB/psf")
  when(member('dc results())
    selectResult('dc)
    mtxP = outfile("/home/mseminario2/vestarv/implementations/asic/castalia/analog/data/raw/dr_wpsu__sf.meta" "w")
    fprintf(mtxP "sweep %%L\n" car(errset(sweepNames())))
    close(mtxP)
    errset(mtxDump("/home/mseminario2/vestarv/implementations/asic/castalia/analog/data/raw/dr_wpsu__sf__code_vdac_min.csv" xmin(VS("/VddDac"))))
    errset(mtxDump("/home/mseminario2/vestarv/implementations/asic/castalia/analog/data/raw/dr_wpsu__sf__dnl_min.csv" ymin(((deriv(VS("/Out")) / ((value(VS("/Out") 4095) - value(VS("/Out") 0)) / 4095)) - 1))))
    errset(mtxDump("/home/mseminario2/vestarv/implementations/asic/castalia/analog/data/raw/dr_wpsu__sf__dnl_n_lsb.csv" ymax(abs(((deriv((VS("/Out") / VS("/VddDac"))) / ((value((VS("/Out") / VS("/VddDac")) 4095) - value((VS("/Out") / VS("/VddDac")) 0)) / 4095)) - 1)))))
    errset(mtxDump("/home/mseminario2/vestarv/implementations/asic/castalia/analog/data/raw/dr_wpsu__sf__dnl_n_min.csv" ymin(((deriv((VS("/Out") / VS("/VddDac"))) / ((value((VS("/Out") / VS("/VddDac")) 4095) - value((VS("/Out") / VS("/VddDac")) 0)) / 4095)) - 1))))
    errset(mtxDump("/home/mseminario2/vestarv/implementations/asic/castalia/analog/data/raw/dr_wpsu__sf__dnl_n_wave.csv" ((deriv((VS("/Out") / VS("/VddDac"))) / ((value((VS("/Out") / VS("/VddDac")) 4095) - value((VS("/Out") / VS("/VddDac")) 0)) / 4095)) - 1)))
    errset(mtxDump("/home/mseminario2/vestarv/implementations/asic/castalia/analog/data/raw/dr_wpsu__sf__gain_err.csv" (((value((VS("/Out") / VS("/VddDac")) 4095) - value((VS("/Out") / VS("/VddDac")) 0)) / (4095.0 / 4096.0)) - 1)))
    errset(mtxDump("/home/mseminario2/vestarv/implementations/asic/castalia/analog/data/raw/dr_wpsu__sf__inl_lsb.csv" ymax(abs(((VS("/Out") - (value(VS("/Out") 0) + (((value(VS("/Out") 4095) - value(VS("/Out") 0)) / 4095) * xval(VS("/Out"))))) / ((value(VS("/Out") 4095) - value(VS("/Out") 0)) / 4095))))))
    errset(mtxDump("/home/mseminario2/vestarv/implementations/asic/castalia/analog/data/raw/dr_wpsu__sf__inl_n_lsb.csv" ymax(abs((((VS("/Out") / VS("/VddDac")) - (value((VS("/Out") / VS("/VddDac")) 0) + (((value((VS("/Out") / VS("/VddDac")) 4095) - value((VS("/Out") / VS("/VddDac")) 0)) / 4095) * xval(VS("/Out"))))) / ((value((VS("/Out") / VS("/VddDac")) 4095) - value((VS("/Out") / VS("/VddDac")) 0)) / 4095))))))
    errset(mtxDump("/home/mseminario2/vestarv/implementations/asic/castalia/analog/data/raw/dr_wpsu__sf__inl_wave.csv" ((VS("/Out") - (value(VS("/Out") 0) + (((value(VS("/Out") 4095) - value(VS("/Out") 0)) / 4095) * xval(VS("/Out"))))) / ((value(VS("/Out") 4095) - value(VS("/Out") 0)) / 4095))))
    errset(mtxDump("/home/mseminario2/vestarv/implementations/asic/castalia/analog/data/raw/dr_wpsu__sf__lsb.csv" ((value(VS("/Out") 4095) - value(VS("/Out") 0)) / 4095)))
    errset(mtxDump("/home/mseminario2/vestarv/implementations/asic/castalia/analog/data/raw/dr_wpsu__sf__v_fs.csv" value(VS("/Out") 4095)))
    errset(mtxDump("/home/mseminario2/vestarv/implementations/asic/castalia/analog/data/raw/dr_wpsu__sf__vddac_dev.csv" (VS("/VddDac") - value(VS("/VddDac") 0))))
    errset(mtxDump("/home/mseminario2/vestarv/implementations/asic/castalia/analog/data/raw/dr_wpsu__sf__vddac_max.csv" ymax(VS("/VddDac"))))
    errset(mtxDump("/home/mseminario2/vestarv/implementations/asic/castalia/analog/data/raw/dr_wpsu__sf__vddac_min.csv" ymin(VS("/VddDac"))))
    errset(mtxDump("/home/mseminario2/vestarv/implementations/asic/castalia/analog/data/raw/dr_wpsu__sf__vddac_pp.csv" (ymax(VS("/VddDac")) - ymin(VS("/VddDac")))))
    errset(mtxDump("/home/mseminario2/vestarv/implementations/asic/castalia/analog/data/raw/dr_wpsu__sf__voff_lsb.csv" (value((VS("/Out") / VS("/VddDac")) 0) / ((value((VS("/Out") / VS("/VddDac")) 4095) - value((VS("/Out") / VS("/VddDac")) 0)) / 4095))))
  )
)

;; ---- corner 4 (sf) / test dr_zout
when(isDir("/home/mseminario2/chips/castalia/ic/.simulation/castalia/tb_anatop_pixel_dacR2R12/maestro/results/maestro/Interactive.34/4/ZoutTB/psf")
  openResults("/home/mseminario2/chips/castalia/ic/.simulation/castalia/tb_anatop_pixel_dacR2R12/maestro/results/maestro/Interactive.34/4/ZoutTB/psf")
  when(member('ac results())
    selectResult('ac)
    mtxP = outfile("/home/mseminario2/vestarv/implementations/asic/castalia/analog/data/raw/dr_zout__sf.meta" "w")
    fprintf(mtxP "sweep %%L\n" car(errset(sweepNames())))
    close(mtxP)
    errset(mtxDump("/home/mseminario2/vestarv/implementations/asic/castalia/analog/data/raw/dr_zout__sf__f_zout_peak.csv" xmax(mag(VF("/VddDac")))))
    errset(mtxDump("/home/mseminario2/vestarv/implementations/asic/castalia/analog/data/raw/dr_zout__sf__zout_100k.csv" value(mag(VF("/VddDac")) 100000)))
    errset(mtxDump("/home/mseminario2/vestarv/implementations/asic/castalia/analog/data/raw/dr_zout__sf__zout_1k.csv" value(mag(VF("/VddDac")) 1000)))
    errset(mtxDump("/home/mseminario2/vestarv/implementations/asic/castalia/analog/data/raw/dr_zout__sf__zout_lf.csv" value(mag(VF("/VddDac")) 1)))
    errset(mtxDump("/home/mseminario2/vestarv/implementations/asic/castalia/analog/data/raw/dr_zout__sf__zout_max.csv" ymax(mag(VF("/VddDac")))))
    errset(mtxDump("/home/mseminario2/vestarv/implementations/asic/castalia/analog/data/raw/dr_zout__sf__zout_wave.csv" mag(VF("/VddDac"))))
  )
)

;; ---- corner 5 (ss) / test dr_ideal
when(isDir("/home/mseminario2/chips/castalia/ic/.simulation/castalia/tb_anatop_pixel_dacR2R12/maestro/results/maestro/Interactive.34/5/DacNonlinTB/psf")
  openResults("/home/mseminario2/chips/castalia/ic/.simulation/castalia/tb_anatop_pixel_dacR2R12/maestro/results/maestro/Interactive.34/5/DacNonlinTB/psf")
  when(member('dc results())
    selectResult('dc)
    mtxP = outfile("/home/mseminario2/vestarv/implementations/asic/castalia/analog/data/raw/dr_ideal__ss.meta" "w")
    fprintf(mtxP "sweep %%L\n" car(errset(sweepNames())))
    close(mtxP)
    errset(mtxDump("/home/mseminario2/vestarv/implementations/asic/castalia/analog/data/raw/dr_ideal__ss__dnl_lsb.csv" ymax(abs(((deriv(VS("/Out")) / ((value(VS("/Out") 4095) - value(VS("/Out") 0)) / 4095)) - 1)))))
    errset(mtxDump("/home/mseminario2/vestarv/implementations/asic/castalia/analog/data/raw/dr_ideal__ss__dnl_max.csv" ymax(((deriv(VS("/Out")) / ((value(VS("/Out") 4095) - value(VS("/Out") 0)) / 4095)) - 1))))
    errset(mtxDump("/home/mseminario2/vestarv/implementations/asic/castalia/analog/data/raw/dr_ideal__ss__dnl_min.csv" ymin(((deriv(VS("/Out")) / ((value(VS("/Out") 4095) - value(VS("/Out") 0)) / 4095)) - 1))))
    errset(mtxDump("/home/mseminario2/vestarv/implementations/asic/castalia/analog/data/raw/dr_ideal__ss__dnl_wave.csv" ((deriv(VS("/Out")) / ((value(VS("/Out") 4095) - value(VS("/Out") 0)) / 4095)) - 1)))
    errset(mtxDump("/home/mseminario2/vestarv/implementations/asic/castalia/analog/data/raw/dr_ideal__ss__inl_lsb.csv" ymax(abs(((VS("/Out") - (value(VS("/Out") 0) + (((value(VS("/Out") 4095) - value(VS("/Out") 0)) / 4095) * xval(VS("/Out"))))) / ((value(VS("/Out") 4095) - value(VS("/Out") 0)) / 4095))))))
    errset(mtxDump("/home/mseminario2/vestarv/implementations/asic/castalia/analog/data/raw/dr_ideal__ss__inl_max.csv" ymax(((VS("/Out") - (value(VS("/Out") 0) + (((value(VS("/Out") 4095) - value(VS("/Out") 0)) / 4095) * xval(VS("/Out"))))) / ((value(VS("/Out") 4095) - value(VS("/Out") 0)) / 4095)))))
    errset(mtxDump("/home/mseminario2/vestarv/implementations/asic/castalia/analog/data/raw/dr_ideal__ss__inl_min.csv" ymin(((VS("/Out") - (value(VS("/Out") 0) + (((value(VS("/Out") 4095) - value(VS("/Out") 0)) / 4095) * xval(VS("/Out"))))) / ((value(VS("/Out") 4095) - value(VS("/Out") 0)) / 4095)))))
    errset(mtxDump("/home/mseminario2/vestarv/implementations/asic/castalia/analog/data/raw/dr_ideal__ss__inl_wave.csv" ((VS("/Out") - (value(VS("/Out") 0) + (((value(VS("/Out") 4095) - value(VS("/Out") 0)) / 4095) * xval(VS("/Out"))))) / ((value(VS("/Out") 4095) - value(VS("/Out") 0)) / 4095))))
    errset(mtxDump("/home/mseminario2/vestarv/implementations/asic/castalia/analog/data/raw/dr_ideal__ss__lsb.csv" ((value(VS("/Out") 4095) - value(VS("/Out") 0)) / 4095)))
    errset(mtxDump("/home/mseminario2/vestarv/implementations/asic/castalia/analog/data/raw/dr_ideal__ss__v_fs.csv" value(VS("/Out") 4095)))
    errset(mtxDump("/home/mseminario2/vestarv/implementations/asic/castalia/analog/data/raw/dr_ideal__ss__v_zs.csv" value(VS("/Out") 0)))
  )
)

;; ---- corner 5 (ss) / test dr_line
when(isDir("/home/mseminario2/chips/castalia/ic/.simulation/castalia/tb_anatop_pixel_dacR2R12/maestro/results/maestro/Interactive.34/5/LineRegTB/psf")
  openResults("/home/mseminario2/chips/castalia/ic/.simulation/castalia/tb_anatop_pixel_dacR2R12/maestro/results/maestro/Interactive.34/5/LineRegTB/psf")
  when(member('dc results())
    selectResult('dc)
    mtxP = outfile("/home/mseminario2/vestarv/implementations/asic/castalia/analog/data/raw/dr_line__ss.meta" "w")
    fprintf(mtxP "sweep %%L\n" car(errset(sweepNames())))
    close(mtxP)
    errset(mtxDump("/home/mseminario2/vestarv/implementations/asic/castalia/analog/data/raw/dr_line__ss__dvddac_line.csv" (value(VS("/VddDac") VAR("vdd_hi")) - value(VS("/VddDac") VAR("vdd_lo")))))
    errset(mtxDump("/home/mseminario2/vestarv/implementations/asic/castalia/analog/data/raw/dr_line__ss__i_q.csv" abs(IDC("/POWER/SRC_VDD25/PLUS"))))
    errset(mtxDump("/home/mseminario2/vestarv/implementations/asic/castalia/analog/data/raw/dr_line__ss__line_reg.csv" ((value(VS("/VddDac") VAR("vdd_hi")) - value(VS("/VddDac") VAR("vdd_lo"))) / (VAR("vdd_hi") - VAR("vdd_lo")))))
    errset(mtxDump("/home/mseminario2/vestarv/implementations/asic/castalia/analog/data/raw/dr_line__ss__vddac_ln.csv" VS("/VddDac")))
    errset(mtxDump("/home/mseminario2/vestarv/implementations/asic/castalia/analog/data/raw/dr_line__ss__vddac_nom.csv" value(VS("/VddDac") VAR("VDD25"))))
  )
)

;; ---- corner 5 (ss) / test dr_load
when(isDir("/home/mseminario2/chips/castalia/ic/.simulation/castalia/tb_anatop_pixel_dacR2R12/maestro/results/maestro/Interactive.34/5/LoadRegTB/psf")
  openResults("/home/mseminario2/chips/castalia/ic/.simulation/castalia/tb_anatop_pixel_dacR2R12/maestro/results/maestro/Interactive.34/5/LoadRegTB/psf")
  when(member('dc results())
    selectResult('dc)
    mtxP = outfile("/home/mseminario2/vestarv/implementations/asic/castalia/analog/data/raw/dr_load__ss.meta" "w")
    fprintf(mtxP "sweep %%L\n" car(errset(sweepNames())))
    close(mtxP)
    errset(mtxDump("/home/mseminario2/vestarv/implementations/asic/castalia/analog/data/raw/dr_load__ss__dvddac_load.csv" (value(VS("/VddDac") 0) - value(VS("/VddDac") VAR("i_load_max")))))
    errset(mtxDump("/home/mseminario2/vestarv/implementations/asic/castalia/analog/data/raw/dr_load__ss__load_reg.csv" ((value(VS("/VddDac") 0) - value(VS("/VddDac") VAR("i_load_max"))) / VAR("i_load_max"))))
    errset(mtxDump("/home/mseminario2/vestarv/implementations/asic/castalia/analog/data/raw/dr_load__ss__vddac_full.csv" value(VS("/VddDac") VAR("i_load_max"))))
    errset(mtxDump("/home/mseminario2/vestarv/implementations/asic/castalia/analog/data/raw/dr_load__ss__vddac_l.csv" VS("/VddDac")))
    errset(mtxDump("/home/mseminario2/vestarv/implementations/asic/castalia/analog/data/raw/dr_load__ss__vddac_noload.csv" value(VS("/VddDac") 0)))
  )
)

;; ---- corner 5 (ss) / test dr_startup
when(isDir("/home/mseminario2/chips/castalia/ic/.simulation/castalia/tb_anatop_pixel_dacR2R12/maestro/results/maestro/Interactive.34/5/PSUStartupTB/psf")
  openResults("/home/mseminario2/chips/castalia/ic/.simulation/castalia/tb_anatop_pixel_dacR2R12/maestro/results/maestro/Interactive.34/5/PSUStartupTB/psf")
  when(member('tran results())
    selectResult('tran)
    mtxP = outfile("/home/mseminario2/vestarv/implementations/asic/castalia/analog/data/raw/dr_startup__ss.meta" "w")
    fprintf(mtxP "sweep %%L\n" car(errset(sweepNames())))
    close(mtxP)
    errset(mtxDump("/home/mseminario2/vestarv/implementations/asic/castalia/analog/data/raw/dr_startup__ss__vddac_t.csv" VT("/VddDac")))
  )
)

;; ---- corner 5 (ss) / test dr_wpsu
when(isDir("/home/mseminario2/chips/castalia/ic/.simulation/castalia/tb_anatop_pixel_dacR2R12/maestro/results/maestro/Interactive.34/5/DacNonlinWPSUTB/psf")
  openResults("/home/mseminario2/chips/castalia/ic/.simulation/castalia/tb_anatop_pixel_dacR2R12/maestro/results/maestro/Interactive.34/5/DacNonlinWPSUTB/psf")
  when(member('dc results())
    selectResult('dc)
    mtxP = outfile("/home/mseminario2/vestarv/implementations/asic/castalia/analog/data/raw/dr_wpsu__ss.meta" "w")
    fprintf(mtxP "sweep %%L\n" car(errset(sweepNames())))
    close(mtxP)
    errset(mtxDump("/home/mseminario2/vestarv/implementations/asic/castalia/analog/data/raw/dr_wpsu__ss__code_vdac_min.csv" xmin(VS("/VddDac"))))
    errset(mtxDump("/home/mseminario2/vestarv/implementations/asic/castalia/analog/data/raw/dr_wpsu__ss__dnl_min.csv" ymin(((deriv(VS("/Out")) / ((value(VS("/Out") 4095) - value(VS("/Out") 0)) / 4095)) - 1))))
    errset(mtxDump("/home/mseminario2/vestarv/implementations/asic/castalia/analog/data/raw/dr_wpsu__ss__dnl_n_lsb.csv" ymax(abs(((deriv((VS("/Out") / VS("/VddDac"))) / ((value((VS("/Out") / VS("/VddDac")) 4095) - value((VS("/Out") / VS("/VddDac")) 0)) / 4095)) - 1)))))
    errset(mtxDump("/home/mseminario2/vestarv/implementations/asic/castalia/analog/data/raw/dr_wpsu__ss__dnl_n_min.csv" ymin(((deriv((VS("/Out") / VS("/VddDac"))) / ((value((VS("/Out") / VS("/VddDac")) 4095) - value((VS("/Out") / VS("/VddDac")) 0)) / 4095)) - 1))))
    errset(mtxDump("/home/mseminario2/vestarv/implementations/asic/castalia/analog/data/raw/dr_wpsu__ss__dnl_n_wave.csv" ((deriv((VS("/Out") / VS("/VddDac"))) / ((value((VS("/Out") / VS("/VddDac")) 4095) - value((VS("/Out") / VS("/VddDac")) 0)) / 4095)) - 1)))
    errset(mtxDump("/home/mseminario2/vestarv/implementations/asic/castalia/analog/data/raw/dr_wpsu__ss__gain_err.csv" (((value((VS("/Out") / VS("/VddDac")) 4095) - value((VS("/Out") / VS("/VddDac")) 0)) / (4095.0 / 4096.0)) - 1)))
    errset(mtxDump("/home/mseminario2/vestarv/implementations/asic/castalia/analog/data/raw/dr_wpsu__ss__inl_lsb.csv" ymax(abs(((VS("/Out") - (value(VS("/Out") 0) + (((value(VS("/Out") 4095) - value(VS("/Out") 0)) / 4095) * xval(VS("/Out"))))) / ((value(VS("/Out") 4095) - value(VS("/Out") 0)) / 4095))))))
    errset(mtxDump("/home/mseminario2/vestarv/implementations/asic/castalia/analog/data/raw/dr_wpsu__ss__inl_n_lsb.csv" ymax(abs((((VS("/Out") / VS("/VddDac")) - (value((VS("/Out") / VS("/VddDac")) 0) + (((value((VS("/Out") / VS("/VddDac")) 4095) - value((VS("/Out") / VS("/VddDac")) 0)) / 4095) * xval(VS("/Out"))))) / ((value((VS("/Out") / VS("/VddDac")) 4095) - value((VS("/Out") / VS("/VddDac")) 0)) / 4095))))))
    errset(mtxDump("/home/mseminario2/vestarv/implementations/asic/castalia/analog/data/raw/dr_wpsu__ss__inl_wave.csv" ((VS("/Out") - (value(VS("/Out") 0) + (((value(VS("/Out") 4095) - value(VS("/Out") 0)) / 4095) * xval(VS("/Out"))))) / ((value(VS("/Out") 4095) - value(VS("/Out") 0)) / 4095))))
    errset(mtxDump("/home/mseminario2/vestarv/implementations/asic/castalia/analog/data/raw/dr_wpsu__ss__lsb.csv" ((value(VS("/Out") 4095) - value(VS("/Out") 0)) / 4095)))
    errset(mtxDump("/home/mseminario2/vestarv/implementations/asic/castalia/analog/data/raw/dr_wpsu__ss__v_fs.csv" value(VS("/Out") 4095)))
    errset(mtxDump("/home/mseminario2/vestarv/implementations/asic/castalia/analog/data/raw/dr_wpsu__ss__vddac_dev.csv" (VS("/VddDac") - value(VS("/VddDac") 0))))
    errset(mtxDump("/home/mseminario2/vestarv/implementations/asic/castalia/analog/data/raw/dr_wpsu__ss__vddac_max.csv" ymax(VS("/VddDac"))))
    errset(mtxDump("/home/mseminario2/vestarv/implementations/asic/castalia/analog/data/raw/dr_wpsu__ss__vddac_min.csv" ymin(VS("/VddDac"))))
    errset(mtxDump("/home/mseminario2/vestarv/implementations/asic/castalia/analog/data/raw/dr_wpsu__ss__vddac_pp.csv" (ymax(VS("/VddDac")) - ymin(VS("/VddDac")))))
    errset(mtxDump("/home/mseminario2/vestarv/implementations/asic/castalia/analog/data/raw/dr_wpsu__ss__voff_lsb.csv" (value((VS("/Out") / VS("/VddDac")) 0) / ((value((VS("/Out") / VS("/VddDac")) 4095) - value((VS("/Out") / VS("/VddDac")) 0)) / 4095))))
  )
)

;; ---- corner 5 (ss) / test dr_zout
when(isDir("/home/mseminario2/chips/castalia/ic/.simulation/castalia/tb_anatop_pixel_dacR2R12/maestro/results/maestro/Interactive.34/5/ZoutTB/psf")
  openResults("/home/mseminario2/chips/castalia/ic/.simulation/castalia/tb_anatop_pixel_dacR2R12/maestro/results/maestro/Interactive.34/5/ZoutTB/psf")
  when(member('ac results())
    selectResult('ac)
    mtxP = outfile("/home/mseminario2/vestarv/implementations/asic/castalia/analog/data/raw/dr_zout__ss.meta" "w")
    fprintf(mtxP "sweep %%L\n" car(errset(sweepNames())))
    close(mtxP)
    errset(mtxDump("/home/mseminario2/vestarv/implementations/asic/castalia/analog/data/raw/dr_zout__ss__f_zout_peak.csv" xmax(mag(VF("/VddDac")))))
    errset(mtxDump("/home/mseminario2/vestarv/implementations/asic/castalia/analog/data/raw/dr_zout__ss__zout_100k.csv" value(mag(VF("/VddDac")) 100000)))
    errset(mtxDump("/home/mseminario2/vestarv/implementations/asic/castalia/analog/data/raw/dr_zout__ss__zout_1k.csv" value(mag(VF("/VddDac")) 1000)))
    errset(mtxDump("/home/mseminario2/vestarv/implementations/asic/castalia/analog/data/raw/dr_zout__ss__zout_lf.csv" value(mag(VF("/VddDac")) 1)))
    errset(mtxDump("/home/mseminario2/vestarv/implementations/asic/castalia/analog/data/raw/dr_zout__ss__zout_max.csv" ymax(mag(VF("/VddDac")))))
    errset(mtxDump("/home/mseminario2/vestarv/implementations/asic/castalia/analog/data/raw/dr_zout__ss__zout_wave.csv" mag(VF("/VddDac"))))
  )
)

printf("MTX_EXTRACT_DONE\n")
exit(0)
