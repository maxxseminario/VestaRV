;; generated by maestro2tex -- do not edit
procedure(mtxDump(fname wv)
  let((xs ys n p)
    p = outfile(fname "w")
    cond(
      (null(wv) fprintf(p "#nil\n"))
      (drIsWaveform(wv)
        xs = drGetWaveformXVec(wv)
        ys = drGetWaveformYVec(wv)
        n = drVectorLength(xs)
        for(i 0 n-1
          fprintf(p "%.10g %.10g\n" drGetElem(xs i) drGetElem(ys i)))
      )
      (t fprintf(p "#scalar %.10g\n" float(wv)))
    )
    close(p)
    t))

;; ---- corner 1 (pt1) / test px_grid_noise
when(isDir("/home/mseminario2/chips/castalia/ic/.simulation/castalia/tb_anatop_pixel/maestro/results/maestro/Interactive.20/1/PotTiaTB/psf")
  openResults("/home/mseminario2/chips/castalia/ic/.simulation/castalia/tb_anatop_pixel/maestro/results/maestro/Interactive.20/1/PotTiaTB/psf")
  when(member('noise results())
    selectResult('noise)
    mtxP = outfile("/home/mseminario2/vestarv/implementations/asic/castalia/analog/data/raw/px_grid_noise__pt1.meta" "w")
    fprintf(mtxP "sweep %%L\n" car(errset(sweepNames())))
    close(mtxP)
    errset(mtxDump("/home/mseminario2/vestarv/implementations/asic/castalia/analog/data/raw/px_grid_noise__pt1__grid_cdl.csv" VAR("cdl_we")))
    errset(mtxDump("/home/mseminario2/vestarv/implementations/asic/castalia/analog/data/raw/px_grid_noise__pt1__grid_rct.csv" VAR("rct_we")))
    errset(mtxDump("/home/mseminario2/vestarv/implementations/asic/castalia/analog/data/raw/px_grid_noise__pt1__grid_rf.csv" VAR("rf")))
    errset(mtxDump("/home/mseminario2/vestarv/implementations/asic/castalia/analog/data/raw/px_grid_noise__pt1__in_rma.csv" (rmsNoise(0.1 1000.0) / VAR("rf"))))
    errset(mtxDump("/home/mseminario2/vestarv/implementations/asic/castalia/analog/data/raw/px_grid_noise__pt1__vn_out.csv" rmsNoise(0.1 1000.0)))
  )
)

;; ---- corner 1 (pt1) / test px_grid_stb
when(isDir("/home/mseminario2/chips/castalia/ic/.simulation/castalia/tb_anatop_pixel/maestro/results/maestro/Interactive.20/1/PotTiaTB/psf")
  openResults("/home/mseminario2/chips/castalia/ic/.simulation/castalia/tb_anatop_pixel/maestro/results/maestro/Interactive.20/1/PotTiaTB/psf")
  when(member('stb results())
    selectResult('stb)
    mtxP = outfile("/home/mseminario2/vestarv/implementations/asic/castalia/analog/data/raw/px_grid_stb__pt1.meta" "w")
    fprintf(mtxP "sweep %%L\n" car(errset(sweepNames())))
    close(mtxP)
    errset(mtxDump("/home/mseminario2/vestarv/implementations/asic/castalia/analog/data/raw/px_grid_stb__pt1__grid_cdl.csv" VAR("cdl_we")))
    errset(mtxDump("/home/mseminario2/vestarv/implementations/asic/castalia/analog/data/raw/px_grid_stb__pt1__grid_rct.csv" VAR("rct_we")))
    errset(mtxDump("/home/mseminario2/vestarv/implementations/asic/castalia/analog/data/raw/px_grid_stb__pt1__grid_rf.csv" VAR("rf")))
    errset(mtxDump("/home/mseminario2/vestarv/implementations/asic/castalia/analog/data/raw/px_grid_stb__pt1__stb_aol_db.csv" value(dB20(getData("loopGain" ?result "stb")) 1)))
    errset(mtxDump("/home/mseminario2/vestarv/implementations/asic/castalia/analog/data/raw/px_grid_stb__pt1__stb_pm.csv" (phaseMargin(getData("loopGain" ?result "stb")) + 180)))
  )
)

;; ---- corner 2 (ff2) / test px_grid_noise
when(isDir("/home/mseminario2/chips/castalia/ic/.simulation/castalia/tb_anatop_pixel/maestro/results/maestro/Interactive.20/2/PotTiaTB/psf")
  openResults("/home/mseminario2/chips/castalia/ic/.simulation/castalia/tb_anatop_pixel/maestro/results/maestro/Interactive.20/2/PotTiaTB/psf")
  when(member('noise results())
    selectResult('noise)
    mtxP = outfile("/home/mseminario2/vestarv/implementations/asic/castalia/analog/data/raw/px_grid_noise__ff2.meta" "w")
    fprintf(mtxP "sweep %%L\n" car(errset(sweepNames())))
    close(mtxP)
    errset(mtxDump("/home/mseminario2/vestarv/implementations/asic/castalia/analog/data/raw/px_grid_noise__ff2__grid_cdl.csv" VAR("cdl_we")))
    errset(mtxDump("/home/mseminario2/vestarv/implementations/asic/castalia/analog/data/raw/px_grid_noise__ff2__grid_rct.csv" VAR("rct_we")))
    errset(mtxDump("/home/mseminario2/vestarv/implementations/asic/castalia/analog/data/raw/px_grid_noise__ff2__grid_rf.csv" VAR("rf")))
    errset(mtxDump("/home/mseminario2/vestarv/implementations/asic/castalia/analog/data/raw/px_grid_noise__ff2__in_rma.csv" (rmsNoise(0.1 1000.0) / VAR("rf"))))
    errset(mtxDump("/home/mseminario2/vestarv/implementations/asic/castalia/analog/data/raw/px_grid_noise__ff2__vn_out.csv" rmsNoise(0.1 1000.0)))
  )
)

;; ---- corner 2 (ff2) / test px_grid_stb
when(isDir("/home/mseminario2/chips/castalia/ic/.simulation/castalia/tb_anatop_pixel/maestro/results/maestro/Interactive.20/2/PotTiaTB/psf")
  openResults("/home/mseminario2/chips/castalia/ic/.simulation/castalia/tb_anatop_pixel/maestro/results/maestro/Interactive.20/2/PotTiaTB/psf")
  when(member('stb results())
    selectResult('stb)
    mtxP = outfile("/home/mseminario2/vestarv/implementations/asic/castalia/analog/data/raw/px_grid_stb__ff2.meta" "w")
    fprintf(mtxP "sweep %%L\n" car(errset(sweepNames())))
    close(mtxP)
    errset(mtxDump("/home/mseminario2/vestarv/implementations/asic/castalia/analog/data/raw/px_grid_stb__ff2__grid_cdl.csv" VAR("cdl_we")))
    errset(mtxDump("/home/mseminario2/vestarv/implementations/asic/castalia/analog/data/raw/px_grid_stb__ff2__grid_rct.csv" VAR("rct_we")))
    errset(mtxDump("/home/mseminario2/vestarv/implementations/asic/castalia/analog/data/raw/px_grid_stb__ff2__grid_rf.csv" VAR("rf")))
    errset(mtxDump("/home/mseminario2/vestarv/implementations/asic/castalia/analog/data/raw/px_grid_stb__ff2__stb_aol_db.csv" value(dB20(getData("loopGain" ?result "stb")) 1)))
    errset(mtxDump("/home/mseminario2/vestarv/implementations/asic/castalia/analog/data/raw/px_grid_stb__ff2__stb_pm.csv" (phaseMargin(getData("loopGain" ?result "stb")) + 180)))
  )
)

;; ---- corner 3 (fs3) / test px_grid_noise
when(isDir("/home/mseminario2/chips/castalia/ic/.simulation/castalia/tb_anatop_pixel/maestro/results/maestro/Interactive.20/3/PotTiaTB/psf")
  openResults("/home/mseminario2/chips/castalia/ic/.simulation/castalia/tb_anatop_pixel/maestro/results/maestro/Interactive.20/3/PotTiaTB/psf")
  when(member('noise results())
    selectResult('noise)
    mtxP = outfile("/home/mseminario2/vestarv/implementations/asic/castalia/analog/data/raw/px_grid_noise__fs3.meta" "w")
    fprintf(mtxP "sweep %%L\n" car(errset(sweepNames())))
    close(mtxP)
    errset(mtxDump("/home/mseminario2/vestarv/implementations/asic/castalia/analog/data/raw/px_grid_noise__fs3__grid_cdl.csv" VAR("cdl_we")))
    errset(mtxDump("/home/mseminario2/vestarv/implementations/asic/castalia/analog/data/raw/px_grid_noise__fs3__grid_rct.csv" VAR("rct_we")))
    errset(mtxDump("/home/mseminario2/vestarv/implementations/asic/castalia/analog/data/raw/px_grid_noise__fs3__grid_rf.csv" VAR("rf")))
    errset(mtxDump("/home/mseminario2/vestarv/implementations/asic/castalia/analog/data/raw/px_grid_noise__fs3__in_rma.csv" (rmsNoise(0.1 1000.0) / VAR("rf"))))
    errset(mtxDump("/home/mseminario2/vestarv/implementations/asic/castalia/analog/data/raw/px_grid_noise__fs3__vn_out.csv" rmsNoise(0.1 1000.0)))
  )
)

;; ---- corner 3 (fs3) / test px_grid_stb
when(isDir("/home/mseminario2/chips/castalia/ic/.simulation/castalia/tb_anatop_pixel/maestro/results/maestro/Interactive.20/3/PotTiaTB/psf")
  openResults("/home/mseminario2/chips/castalia/ic/.simulation/castalia/tb_anatop_pixel/maestro/results/maestro/Interactive.20/3/PotTiaTB/psf")
  when(member('stb results())
    selectResult('stb)
    mtxP = outfile("/home/mseminario2/vestarv/implementations/asic/castalia/analog/data/raw/px_grid_stb__fs3.meta" "w")
    fprintf(mtxP "sweep %%L\n" car(errset(sweepNames())))
    close(mtxP)
    errset(mtxDump("/home/mseminario2/vestarv/implementations/asic/castalia/analog/data/raw/px_grid_stb__fs3__grid_cdl.csv" VAR("cdl_we")))
    errset(mtxDump("/home/mseminario2/vestarv/implementations/asic/castalia/analog/data/raw/px_grid_stb__fs3__grid_rct.csv" VAR("rct_we")))
    errset(mtxDump("/home/mseminario2/vestarv/implementations/asic/castalia/analog/data/raw/px_grid_stb__fs3__grid_rf.csv" VAR("rf")))
    errset(mtxDump("/home/mseminario2/vestarv/implementations/asic/castalia/analog/data/raw/px_grid_stb__fs3__stb_aol_db.csv" value(dB20(getData("loopGain" ?result "stb")) 1)))
    errset(mtxDump("/home/mseminario2/vestarv/implementations/asic/castalia/analog/data/raw/px_grid_stb__fs3__stb_pm.csv" (phaseMargin(getData("loopGain" ?result "stb")) + 180)))
  )
)

;; ---- corner 4 (sf4) / test px_grid_noise
when(isDir("/home/mseminario2/chips/castalia/ic/.simulation/castalia/tb_anatop_pixel/maestro/results/maestro/Interactive.20/4/PotTiaTB/psf")
  openResults("/home/mseminario2/chips/castalia/ic/.simulation/castalia/tb_anatop_pixel/maestro/results/maestro/Interactive.20/4/PotTiaTB/psf")
  when(member('noise results())
    selectResult('noise)
    mtxP = outfile("/home/mseminario2/vestarv/implementations/asic/castalia/analog/data/raw/px_grid_noise__sf4.meta" "w")
    fprintf(mtxP "sweep %%L\n" car(errset(sweepNames())))
    close(mtxP)
    errset(mtxDump("/home/mseminario2/vestarv/implementations/asic/castalia/analog/data/raw/px_grid_noise__sf4__grid_cdl.csv" VAR("cdl_we")))
    errset(mtxDump("/home/mseminario2/vestarv/implementations/asic/castalia/analog/data/raw/px_grid_noise__sf4__grid_rct.csv" VAR("rct_we")))
    errset(mtxDump("/home/mseminario2/vestarv/implementations/asic/castalia/analog/data/raw/px_grid_noise__sf4__grid_rf.csv" VAR("rf")))
    errset(mtxDump("/home/mseminario2/vestarv/implementations/asic/castalia/analog/data/raw/px_grid_noise__sf4__in_rma.csv" (rmsNoise(0.1 1000.0) / VAR("rf"))))
    errset(mtxDump("/home/mseminario2/vestarv/implementations/asic/castalia/analog/data/raw/px_grid_noise__sf4__vn_out.csv" rmsNoise(0.1 1000.0)))
  )
)

;; ---- corner 4 (sf4) / test px_grid_stb
when(isDir("/home/mseminario2/chips/castalia/ic/.simulation/castalia/tb_anatop_pixel/maestro/results/maestro/Interactive.20/4/PotTiaTB/psf")
  openResults("/home/mseminario2/chips/castalia/ic/.simulation/castalia/tb_anatop_pixel/maestro/results/maestro/Interactive.20/4/PotTiaTB/psf")
  when(member('stb results())
    selectResult('stb)
    mtxP = outfile("/home/mseminario2/vestarv/implementations/asic/castalia/analog/data/raw/px_grid_stb__sf4.meta" "w")
    fprintf(mtxP "sweep %%L\n" car(errset(sweepNames())))
    close(mtxP)
    errset(mtxDump("/home/mseminario2/vestarv/implementations/asic/castalia/analog/data/raw/px_grid_stb__sf4__grid_cdl.csv" VAR("cdl_we")))
    errset(mtxDump("/home/mseminario2/vestarv/implementations/asic/castalia/analog/data/raw/px_grid_stb__sf4__grid_rct.csv" VAR("rct_we")))
    errset(mtxDump("/home/mseminario2/vestarv/implementations/asic/castalia/analog/data/raw/px_grid_stb__sf4__grid_rf.csv" VAR("rf")))
    errset(mtxDump("/home/mseminario2/vestarv/implementations/asic/castalia/analog/data/raw/px_grid_stb__sf4__stb_aol_db.csv" value(dB20(getData("loopGain" ?result "stb")) 1)))
    errset(mtxDump("/home/mseminario2/vestarv/implementations/asic/castalia/analog/data/raw/px_grid_stb__sf4__stb_pm.csv" (phaseMargin(getData("loopGain" ?result "stb")) + 180)))
  )
)

;; ---- corner 5 (ss5) / test px_grid_noise
when(isDir("/home/mseminario2/chips/castalia/ic/.simulation/castalia/tb_anatop_pixel/maestro/results/maestro/Interactive.20/5/PotTiaTB/psf")
  openResults("/home/mseminario2/chips/castalia/ic/.simulation/castalia/tb_anatop_pixel/maestro/results/maestro/Interactive.20/5/PotTiaTB/psf")
  when(member('noise results())
    selectResult('noise)
    mtxP = outfile("/home/mseminario2/vestarv/implementations/asic/castalia/analog/data/raw/px_grid_noise__ss5.meta" "w")
    fprintf(mtxP "sweep %%L\n" car(errset(sweepNames())))
    close(mtxP)
    errset(mtxDump("/home/mseminario2/vestarv/implementations/asic/castalia/analog/data/raw/px_grid_noise__ss5__grid_cdl.csv" VAR("cdl_we")))
    errset(mtxDump("/home/mseminario2/vestarv/implementations/asic/castalia/analog/data/raw/px_grid_noise__ss5__grid_rct.csv" VAR("rct_we")))
    errset(mtxDump("/home/mseminario2/vestarv/implementations/asic/castalia/analog/data/raw/px_grid_noise__ss5__grid_rf.csv" VAR("rf")))
    errset(mtxDump("/home/mseminario2/vestarv/implementations/asic/castalia/analog/data/raw/px_grid_noise__ss5__in_rma.csv" (rmsNoise(0.1 1000.0) / VAR("rf"))))
    errset(mtxDump("/home/mseminario2/vestarv/implementations/asic/castalia/analog/data/raw/px_grid_noise__ss5__vn_out.csv" rmsNoise(0.1 1000.0)))
  )
)

;; ---- corner 5 (ss5) / test px_grid_stb
when(isDir("/home/mseminario2/chips/castalia/ic/.simulation/castalia/tb_anatop_pixel/maestro/results/maestro/Interactive.20/5/PotTiaTB/psf")
  openResults("/home/mseminario2/chips/castalia/ic/.simulation/castalia/tb_anatop_pixel/maestro/results/maestro/Interactive.20/5/PotTiaTB/psf")
  when(member('stb results())
    selectResult('stb)
    mtxP = outfile("/home/mseminario2/vestarv/implementations/asic/castalia/analog/data/raw/px_grid_stb__ss5.meta" "w")
    fprintf(mtxP "sweep %%L\n" car(errset(sweepNames())))
    close(mtxP)
    errset(mtxDump("/home/mseminario2/vestarv/implementations/asic/castalia/analog/data/raw/px_grid_stb__ss5__grid_cdl.csv" VAR("cdl_we")))
    errset(mtxDump("/home/mseminario2/vestarv/implementations/asic/castalia/analog/data/raw/px_grid_stb__ss5__grid_rct.csv" VAR("rct_we")))
    errset(mtxDump("/home/mseminario2/vestarv/implementations/asic/castalia/analog/data/raw/px_grid_stb__ss5__grid_rf.csv" VAR("rf")))
    errset(mtxDump("/home/mseminario2/vestarv/implementations/asic/castalia/analog/data/raw/px_grid_stb__ss5__stb_aol_db.csv" value(dB20(getData("loopGain" ?result "stb")) 1)))
    errset(mtxDump("/home/mseminario2/vestarv/implementations/asic/castalia/analog/data/raw/px_grid_stb__ss5__stb_pm.csv" (phaseMargin(getData("loopGain" ?result "stb")) + 180)))
  )
)

;; ---- corner 6 (pt6) / test px_grid_noise
when(isDir("/home/mseminario2/chips/castalia/ic/.simulation/castalia/tb_anatop_pixel/maestro/results/maestro/Interactive.20/6/PotTiaTB/psf")
  openResults("/home/mseminario2/chips/castalia/ic/.simulation/castalia/tb_anatop_pixel/maestro/results/maestro/Interactive.20/6/PotTiaTB/psf")
  when(member('noise results())
    selectResult('noise)
    mtxP = outfile("/home/mseminario2/vestarv/implementations/asic/castalia/analog/data/raw/px_grid_noise__pt6.meta" "w")
    fprintf(mtxP "sweep %%L\n" car(errset(sweepNames())))
    close(mtxP)
    errset(mtxDump("/home/mseminario2/vestarv/implementations/asic/castalia/analog/data/raw/px_grid_noise__pt6__grid_cdl.csv" VAR("cdl_we")))
    errset(mtxDump("/home/mseminario2/vestarv/implementations/asic/castalia/analog/data/raw/px_grid_noise__pt6__grid_rct.csv" VAR("rct_we")))
    errset(mtxDump("/home/mseminario2/vestarv/implementations/asic/castalia/analog/data/raw/px_grid_noise__pt6__grid_rf.csv" VAR("rf")))
    errset(mtxDump("/home/mseminario2/vestarv/implementations/asic/castalia/analog/data/raw/px_grid_noise__pt6__in_rma.csv" (rmsNoise(0.1 1000.0) / VAR("rf"))))
    errset(mtxDump("/home/mseminario2/vestarv/implementations/asic/castalia/analog/data/raw/px_grid_noise__pt6__vn_out.csv" rmsNoise(0.1 1000.0)))
  )
)

;; ---- corner 6 (pt6) / test px_grid_stb
when(isDir("/home/mseminario2/chips/castalia/ic/.simulation/castalia/tb_anatop_pixel/maestro/results/maestro/Interactive.20/6/PotTiaTB/psf")
  openResults("/home/mseminario2/chips/castalia/ic/.simulation/castalia/tb_anatop_pixel/maestro/results/maestro/Interactive.20/6/PotTiaTB/psf")
  when(member('stb results())
    selectResult('stb)
    mtxP = outfile("/home/mseminario2/vestarv/implementations/asic/castalia/analog/data/raw/px_grid_stb__pt6.meta" "w")
    fprintf(mtxP "sweep %%L\n" car(errset(sweepNames())))
    close(mtxP)
    errset(mtxDump("/home/mseminario2/vestarv/implementations/asic/castalia/analog/data/raw/px_grid_stb__pt6__grid_cdl.csv" VAR("cdl_we")))
    errset(mtxDump("/home/mseminario2/vestarv/implementations/asic/castalia/analog/data/raw/px_grid_stb__pt6__grid_rct.csv" VAR("rct_we")))
    errset(mtxDump("/home/mseminario2/vestarv/implementations/asic/castalia/analog/data/raw/px_grid_stb__pt6__grid_rf.csv" VAR("rf")))
    errset(mtxDump("/home/mseminario2/vestarv/implementations/asic/castalia/analog/data/raw/px_grid_stb__pt6__stb_aol_db.csv" value(dB20(getData("loopGain" ?result "stb")) 1)))
    errset(mtxDump("/home/mseminario2/vestarv/implementations/asic/castalia/analog/data/raw/px_grid_stb__pt6__stb_pm.csv" (phaseMargin(getData("loopGain" ?result "stb")) + 180)))
  )
)

;; ---- corner 7 (ff7) / test px_grid_noise
when(isDir("/home/mseminario2/chips/castalia/ic/.simulation/castalia/tb_anatop_pixel/maestro/results/maestro/Interactive.20/7/PotTiaTB/psf")
  openResults("/home/mseminario2/chips/castalia/ic/.simulation/castalia/tb_anatop_pixel/maestro/results/maestro/Interactive.20/7/PotTiaTB/psf")
  when(member('noise results())
    selectResult('noise)
    mtxP = outfile("/home/mseminario2/vestarv/implementations/asic/castalia/analog/data/raw/px_grid_noise__ff7.meta" "w")
    fprintf(mtxP "sweep %%L\n" car(errset(sweepNames())))
    close(mtxP)
    errset(mtxDump("/home/mseminario2/vestarv/implementations/asic/castalia/analog/data/raw/px_grid_noise__ff7__grid_cdl.csv" VAR("cdl_we")))
    errset(mtxDump("/home/mseminario2/vestarv/implementations/asic/castalia/analog/data/raw/px_grid_noise__ff7__grid_rct.csv" VAR("rct_we")))
    errset(mtxDump("/home/mseminario2/vestarv/implementations/asic/castalia/analog/data/raw/px_grid_noise__ff7__grid_rf.csv" VAR("rf")))
    errset(mtxDump("/home/mseminario2/vestarv/implementations/asic/castalia/analog/data/raw/px_grid_noise__ff7__in_rma.csv" (rmsNoise(0.1 1000.0) / VAR("rf"))))
    errset(mtxDump("/home/mseminario2/vestarv/implementations/asic/castalia/analog/data/raw/px_grid_noise__ff7__vn_out.csv" rmsNoise(0.1 1000.0)))
  )
)

;; ---- corner 7 (ff7) / test px_grid_stb
when(isDir("/home/mseminario2/chips/castalia/ic/.simulation/castalia/tb_anatop_pixel/maestro/results/maestro/Interactive.20/7/PotTiaTB/psf")
  openResults("/home/mseminario2/chips/castalia/ic/.simulation/castalia/tb_anatop_pixel/maestro/results/maestro/Interactive.20/7/PotTiaTB/psf")
  when(member('stb results())
    selectResult('stb)
    mtxP = outfile("/home/mseminario2/vestarv/implementations/asic/castalia/analog/data/raw/px_grid_stb__ff7.meta" "w")
    fprintf(mtxP "sweep %%L\n" car(errset(sweepNames())))
    close(mtxP)
    errset(mtxDump("/home/mseminario2/vestarv/implementations/asic/castalia/analog/data/raw/px_grid_stb__ff7__grid_cdl.csv" VAR("cdl_we")))
    errset(mtxDump("/home/mseminario2/vestarv/implementations/asic/castalia/analog/data/raw/px_grid_stb__ff7__grid_rct.csv" VAR("rct_we")))
    errset(mtxDump("/home/mseminario2/vestarv/implementations/asic/castalia/analog/data/raw/px_grid_stb__ff7__grid_rf.csv" VAR("rf")))
    errset(mtxDump("/home/mseminario2/vestarv/implementations/asic/castalia/analog/data/raw/px_grid_stb__ff7__stb_aol_db.csv" value(dB20(getData("loopGain" ?result "stb")) 1)))
    errset(mtxDump("/home/mseminario2/vestarv/implementations/asic/castalia/analog/data/raw/px_grid_stb__ff7__stb_pm.csv" (phaseMargin(getData("loopGain" ?result "stb")) + 180)))
  )
)

;; ---- corner 8 (fs8) / test px_grid_noise
when(isDir("/home/mseminario2/chips/castalia/ic/.simulation/castalia/tb_anatop_pixel/maestro/results/maestro/Interactive.20/8/PotTiaTB/psf")
  openResults("/home/mseminario2/chips/castalia/ic/.simulation/castalia/tb_anatop_pixel/maestro/results/maestro/Interactive.20/8/PotTiaTB/psf")
  when(member('noise results())
    selectResult('noise)
    mtxP = outfile("/home/mseminario2/vestarv/implementations/asic/castalia/analog/data/raw/px_grid_noise__fs8.meta" "w")
    fprintf(mtxP "sweep %%L\n" car(errset(sweepNames())))
    close(mtxP)
    errset(mtxDump("/home/mseminario2/vestarv/implementations/asic/castalia/analog/data/raw/px_grid_noise__fs8__grid_cdl.csv" VAR("cdl_we")))
    errset(mtxDump("/home/mseminario2/vestarv/implementations/asic/castalia/analog/data/raw/px_grid_noise__fs8__grid_rct.csv" VAR("rct_we")))
    errset(mtxDump("/home/mseminario2/vestarv/implementations/asic/castalia/analog/data/raw/px_grid_noise__fs8__grid_rf.csv" VAR("rf")))
    errset(mtxDump("/home/mseminario2/vestarv/implementations/asic/castalia/analog/data/raw/px_grid_noise__fs8__in_rma.csv" (rmsNoise(0.1 1000.0) / VAR("rf"))))
    errset(mtxDump("/home/mseminario2/vestarv/implementations/asic/castalia/analog/data/raw/px_grid_noise__fs8__vn_out.csv" rmsNoise(0.1 1000.0)))
  )
)

;; ---- corner 8 (fs8) / test px_grid_stb
when(isDir("/home/mseminario2/chips/castalia/ic/.simulation/castalia/tb_anatop_pixel/maestro/results/maestro/Interactive.20/8/PotTiaTB/psf")
  openResults("/home/mseminario2/chips/castalia/ic/.simulation/castalia/tb_anatop_pixel/maestro/results/maestro/Interactive.20/8/PotTiaTB/psf")
  when(member('stb results())
    selectResult('stb)
    mtxP = outfile("/home/mseminario2/vestarv/implementations/asic/castalia/analog/data/raw/px_grid_stb__fs8.meta" "w")
    fprintf(mtxP "sweep %%L\n" car(errset(sweepNames())))
    close(mtxP)
    errset(mtxDump("/home/mseminario2/vestarv/implementations/asic/castalia/analog/data/raw/px_grid_stb__fs8__grid_cdl.csv" VAR("cdl_we")))
    errset(mtxDump("/home/mseminario2/vestarv/implementations/asic/castalia/analog/data/raw/px_grid_stb__fs8__grid_rct.csv" VAR("rct_we")))
    errset(mtxDump("/home/mseminario2/vestarv/implementations/asic/castalia/analog/data/raw/px_grid_stb__fs8__grid_rf.csv" VAR("rf")))
    errset(mtxDump("/home/mseminario2/vestarv/implementations/asic/castalia/analog/data/raw/px_grid_stb__fs8__stb_aol_db.csv" value(dB20(getData("loopGain" ?result "stb")) 1)))
    errset(mtxDump("/home/mseminario2/vestarv/implementations/asic/castalia/analog/data/raw/px_grid_stb__fs8__stb_pm.csv" (phaseMargin(getData("loopGain" ?result "stb")) + 180)))
  )
)

;; ---- corner 9 (sf9) / test px_grid_noise
when(isDir("/home/mseminario2/chips/castalia/ic/.simulation/castalia/tb_anatop_pixel/maestro/results/maestro/Interactive.20/9/PotTiaTB/psf")
  openResults("/home/mseminario2/chips/castalia/ic/.simulation/castalia/tb_anatop_pixel/maestro/results/maestro/Interactive.20/9/PotTiaTB/psf")
  when(member('noise results())
    selectResult('noise)
    mtxP = outfile("/home/mseminario2/vestarv/implementations/asic/castalia/analog/data/raw/px_grid_noise__sf9.meta" "w")
    fprintf(mtxP "sweep %%L\n" car(errset(sweepNames())))
    close(mtxP)
    errset(mtxDump("/home/mseminario2/vestarv/implementations/asic/castalia/analog/data/raw/px_grid_noise__sf9__grid_cdl.csv" VAR("cdl_we")))
    errset(mtxDump("/home/mseminario2/vestarv/implementations/asic/castalia/analog/data/raw/px_grid_noise__sf9__grid_rct.csv" VAR("rct_we")))
    errset(mtxDump("/home/mseminario2/vestarv/implementations/asic/castalia/analog/data/raw/px_grid_noise__sf9__grid_rf.csv" VAR("rf")))
    errset(mtxDump("/home/mseminario2/vestarv/implementations/asic/castalia/analog/data/raw/px_grid_noise__sf9__in_rma.csv" (rmsNoise(0.1 1000.0) / VAR("rf"))))
    errset(mtxDump("/home/mseminario2/vestarv/implementations/asic/castalia/analog/data/raw/px_grid_noise__sf9__vn_out.csv" rmsNoise(0.1 1000.0)))
  )
)

;; ---- corner 9 (sf9) / test px_grid_stb
when(isDir("/home/mseminario2/chips/castalia/ic/.simulation/castalia/tb_anatop_pixel/maestro/results/maestro/Interactive.20/9/PotTiaTB/psf")
  openResults("/home/mseminario2/chips/castalia/ic/.simulation/castalia/tb_anatop_pixel/maestro/results/maestro/Interactive.20/9/PotTiaTB/psf")
  when(member('stb results())
    selectResult('stb)
    mtxP = outfile("/home/mseminario2/vestarv/implementations/asic/castalia/analog/data/raw/px_grid_stb__sf9.meta" "w")
    fprintf(mtxP "sweep %%L\n" car(errset(sweepNames())))
    close(mtxP)
    errset(mtxDump("/home/mseminario2/vestarv/implementations/asic/castalia/analog/data/raw/px_grid_stb__sf9__grid_cdl.csv" VAR("cdl_we")))
    errset(mtxDump("/home/mseminario2/vestarv/implementations/asic/castalia/analog/data/raw/px_grid_stb__sf9__grid_rct.csv" VAR("rct_we")))
    errset(mtxDump("/home/mseminario2/vestarv/implementations/asic/castalia/analog/data/raw/px_grid_stb__sf9__grid_rf.csv" VAR("rf")))
    errset(mtxDump("/home/mseminario2/vestarv/implementations/asic/castalia/analog/data/raw/px_grid_stb__sf9__stb_aol_db.csv" value(dB20(getData("loopGain" ?result "stb")) 1)))
    errset(mtxDump("/home/mseminario2/vestarv/implementations/asic/castalia/analog/data/raw/px_grid_stb__sf9__stb_pm.csv" (phaseMargin(getData("loopGain" ?result "stb")) + 180)))
  )
)

;; ---- corner 10 (ss10) / test px_grid_noise
when(isDir("/home/mseminario2/chips/castalia/ic/.simulation/castalia/tb_anatop_pixel/maestro/results/maestro/Interactive.20/10/PotTiaTB/psf")
  openResults("/home/mseminario2/chips/castalia/ic/.simulation/castalia/tb_anatop_pixel/maestro/results/maestro/Interactive.20/10/PotTiaTB/psf")
  when(member('noise results())
    selectResult('noise)
    mtxP = outfile("/home/mseminario2/vestarv/implementations/asic/castalia/analog/data/raw/px_grid_noise__ss10.meta" "w")
    fprintf(mtxP "sweep %%L\n" car(errset(sweepNames())))
    close(mtxP)
    errset(mtxDump("/home/mseminario2/vestarv/implementations/asic/castalia/analog/data/raw/px_grid_noise__ss10__grid_cdl.csv" VAR("cdl_we")))
    errset(mtxDump("/home/mseminario2/vestarv/implementations/asic/castalia/analog/data/raw/px_grid_noise__ss10__grid_rct.csv" VAR("rct_we")))
    errset(mtxDump("/home/mseminario2/vestarv/implementations/asic/castalia/analog/data/raw/px_grid_noise__ss10__grid_rf.csv" VAR("rf")))
    errset(mtxDump("/home/mseminario2/vestarv/implementations/asic/castalia/analog/data/raw/px_grid_noise__ss10__in_rma.csv" (rmsNoise(0.1 1000.0) / VAR("rf"))))
    errset(mtxDump("/home/mseminario2/vestarv/implementations/asic/castalia/analog/data/raw/px_grid_noise__ss10__vn_out.csv" rmsNoise(0.1 1000.0)))
  )
)

;; ---- corner 10 (ss10) / test px_grid_stb
when(isDir("/home/mseminario2/chips/castalia/ic/.simulation/castalia/tb_anatop_pixel/maestro/results/maestro/Interactive.20/10/PotTiaTB/psf")
  openResults("/home/mseminario2/chips/castalia/ic/.simulation/castalia/tb_anatop_pixel/maestro/results/maestro/Interactive.20/10/PotTiaTB/psf")
  when(member('stb results())
    selectResult('stb)
    mtxP = outfile("/home/mseminario2/vestarv/implementations/asic/castalia/analog/data/raw/px_grid_stb__ss10.meta" "w")
    fprintf(mtxP "sweep %%L\n" car(errset(sweepNames())))
    close(mtxP)
    errset(mtxDump("/home/mseminario2/vestarv/implementations/asic/castalia/analog/data/raw/px_grid_stb__ss10__grid_cdl.csv" VAR("cdl_we")))
    errset(mtxDump("/home/mseminario2/vestarv/implementations/asic/castalia/analog/data/raw/px_grid_stb__ss10__grid_rct.csv" VAR("rct_we")))
    errset(mtxDump("/home/mseminario2/vestarv/implementations/asic/castalia/analog/data/raw/px_grid_stb__ss10__grid_rf.csv" VAR("rf")))
    errset(mtxDump("/home/mseminario2/vestarv/implementations/asic/castalia/analog/data/raw/px_grid_stb__ss10__stb_aol_db.csv" value(dB20(getData("loopGain" ?result "stb")) 1)))
    errset(mtxDump("/home/mseminario2/vestarv/implementations/asic/castalia/analog/data/raw/px_grid_stb__ss10__stb_pm.csv" (phaseMargin(getData("loopGain" ?result "stb")) + 180)))
  )
)

;; ---- corner 11 (pt11) / test px_grid_noise
when(isDir("/home/mseminario2/chips/castalia/ic/.simulation/castalia/tb_anatop_pixel/maestro/results/maestro/Interactive.20/11/PotTiaTB/psf")
  openResults("/home/mseminario2/chips/castalia/ic/.simulation/castalia/tb_anatop_pixel/maestro/results/maestro/Interactive.20/11/PotTiaTB/psf")
  when(member('noise results())
    selectResult('noise)
    mtxP = outfile("/home/mseminario2/vestarv/implementations/asic/castalia/analog/data/raw/px_grid_noise__pt11.meta" "w")
    fprintf(mtxP "sweep %%L\n" car(errset(sweepNames())))
    close(mtxP)
    errset(mtxDump("/home/mseminario2/vestarv/implementations/asic/castalia/analog/data/raw/px_grid_noise__pt11__grid_cdl.csv" VAR("cdl_we")))
    errset(mtxDump("/home/mseminario2/vestarv/implementations/asic/castalia/analog/data/raw/px_grid_noise__pt11__grid_rct.csv" VAR("rct_we")))
    errset(mtxDump("/home/mseminario2/vestarv/implementations/asic/castalia/analog/data/raw/px_grid_noise__pt11__grid_rf.csv" VAR("rf")))
    errset(mtxDump("/home/mseminario2/vestarv/implementations/asic/castalia/analog/data/raw/px_grid_noise__pt11__in_rma.csv" (rmsNoise(0.1 1000.0) / VAR("rf"))))
    errset(mtxDump("/home/mseminario2/vestarv/implementations/asic/castalia/analog/data/raw/px_grid_noise__pt11__vn_out.csv" rmsNoise(0.1 1000.0)))
  )
)

;; ---- corner 11 (pt11) / test px_grid_stb
when(isDir("/home/mseminario2/chips/castalia/ic/.simulation/castalia/tb_anatop_pixel/maestro/results/maestro/Interactive.20/11/PotTiaTB/psf")
  openResults("/home/mseminario2/chips/castalia/ic/.simulation/castalia/tb_anatop_pixel/maestro/results/maestro/Interactive.20/11/PotTiaTB/psf")
  when(member('stb results())
    selectResult('stb)
    mtxP = outfile("/home/mseminario2/vestarv/implementations/asic/castalia/analog/data/raw/px_grid_stb__pt11.meta" "w")
    fprintf(mtxP "sweep %%L\n" car(errset(sweepNames())))
    close(mtxP)
    errset(mtxDump("/home/mseminario2/vestarv/implementations/asic/castalia/analog/data/raw/px_grid_stb__pt11__grid_cdl.csv" VAR("cdl_we")))
    errset(mtxDump("/home/mseminario2/vestarv/implementations/asic/castalia/analog/data/raw/px_grid_stb__pt11__grid_rct.csv" VAR("rct_we")))
    errset(mtxDump("/home/mseminario2/vestarv/implementations/asic/castalia/analog/data/raw/px_grid_stb__pt11__grid_rf.csv" VAR("rf")))
    errset(mtxDump("/home/mseminario2/vestarv/implementations/asic/castalia/analog/data/raw/px_grid_stb__pt11__stb_aol_db.csv" value(dB20(getData("loopGain" ?result "stb")) 1)))
    errset(mtxDump("/home/mseminario2/vestarv/implementations/asic/castalia/analog/data/raw/px_grid_stb__pt11__stb_pm.csv" (phaseMargin(getData("loopGain" ?result "stb")) + 180)))
  )
)

;; ---- corner 12 (ff12) / test px_grid_noise
when(isDir("/home/mseminario2/chips/castalia/ic/.simulation/castalia/tb_anatop_pixel/maestro/results/maestro/Interactive.20/12/PotTiaTB/psf")
  openResults("/home/mseminario2/chips/castalia/ic/.simulation/castalia/tb_anatop_pixel/maestro/results/maestro/Interactive.20/12/PotTiaTB/psf")
  when(member('noise results())
    selectResult('noise)
    mtxP = outfile("/home/mseminario2/vestarv/implementations/asic/castalia/analog/data/raw/px_grid_noise__ff12.meta" "w")
    fprintf(mtxP "sweep %%L\n" car(errset(sweepNames())))
    close(mtxP)
    errset(mtxDump("/home/mseminario2/vestarv/implementations/asic/castalia/analog/data/raw/px_grid_noise__ff12__grid_cdl.csv" VAR("cdl_we")))
    errset(mtxDump("/home/mseminario2/vestarv/implementations/asic/castalia/analog/data/raw/px_grid_noise__ff12__grid_rct.csv" VAR("rct_we")))
    errset(mtxDump("/home/mseminario2/vestarv/implementations/asic/castalia/analog/data/raw/px_grid_noise__ff12__grid_rf.csv" VAR("rf")))
    errset(mtxDump("/home/mseminario2/vestarv/implementations/asic/castalia/analog/data/raw/px_grid_noise__ff12__in_rma.csv" (rmsNoise(0.1 1000.0) / VAR("rf"))))
    errset(mtxDump("/home/mseminario2/vestarv/implementations/asic/castalia/analog/data/raw/px_grid_noise__ff12__vn_out.csv" rmsNoise(0.1 1000.0)))
  )
)

;; ---- corner 12 (ff12) / test px_grid_stb
when(isDir("/home/mseminario2/chips/castalia/ic/.simulation/castalia/tb_anatop_pixel/maestro/results/maestro/Interactive.20/12/PotTiaTB/psf")
  openResults("/home/mseminario2/chips/castalia/ic/.simulation/castalia/tb_anatop_pixel/maestro/results/maestro/Interactive.20/12/PotTiaTB/psf")
  when(member('stb results())
    selectResult('stb)
    mtxP = outfile("/home/mseminario2/vestarv/implementations/asic/castalia/analog/data/raw/px_grid_stb__ff12.meta" "w")
    fprintf(mtxP "sweep %%L\n" car(errset(sweepNames())))
    close(mtxP)
    errset(mtxDump("/home/mseminario2/vestarv/implementations/asic/castalia/analog/data/raw/px_grid_stb__ff12__grid_cdl.csv" VAR("cdl_we")))
    errset(mtxDump("/home/mseminario2/vestarv/implementations/asic/castalia/analog/data/raw/px_grid_stb__ff12__grid_rct.csv" VAR("rct_we")))
    errset(mtxDump("/home/mseminario2/vestarv/implementations/asic/castalia/analog/data/raw/px_grid_stb__ff12__grid_rf.csv" VAR("rf")))
    errset(mtxDump("/home/mseminario2/vestarv/implementations/asic/castalia/analog/data/raw/px_grid_stb__ff12__stb_aol_db.csv" value(dB20(getData("loopGain" ?result "stb")) 1)))
    errset(mtxDump("/home/mseminario2/vestarv/implementations/asic/castalia/analog/data/raw/px_grid_stb__ff12__stb_pm.csv" (phaseMargin(getData("loopGain" ?result "stb")) + 180)))
  )
)

;; ---- corner 13 (fs13) / test px_grid_noise
when(isDir("/home/mseminario2/chips/castalia/ic/.simulation/castalia/tb_anatop_pixel/maestro/results/maestro/Interactive.20/13/PotTiaTB/psf")
  openResults("/home/mseminario2/chips/castalia/ic/.simulation/castalia/tb_anatop_pixel/maestro/results/maestro/Interactive.20/13/PotTiaTB/psf")
  when(member('noise results())
    selectResult('noise)
    mtxP = outfile("/home/mseminario2/vestarv/implementations/asic/castalia/analog/data/raw/px_grid_noise__fs13.meta" "w")
    fprintf(mtxP "sweep %%L\n" car(errset(sweepNames())))
    close(mtxP)
    errset(mtxDump("/home/mseminario2/vestarv/implementations/asic/castalia/analog/data/raw/px_grid_noise__fs13__grid_cdl.csv" VAR("cdl_we")))
    errset(mtxDump("/home/mseminario2/vestarv/implementations/asic/castalia/analog/data/raw/px_grid_noise__fs13__grid_rct.csv" VAR("rct_we")))
    errset(mtxDump("/home/mseminario2/vestarv/implementations/asic/castalia/analog/data/raw/px_grid_noise__fs13__grid_rf.csv" VAR("rf")))
    errset(mtxDump("/home/mseminario2/vestarv/implementations/asic/castalia/analog/data/raw/px_grid_noise__fs13__in_rma.csv" (rmsNoise(0.1 1000.0) / VAR("rf"))))
    errset(mtxDump("/home/mseminario2/vestarv/implementations/asic/castalia/analog/data/raw/px_grid_noise__fs13__vn_out.csv" rmsNoise(0.1 1000.0)))
  )
)

;; ---- corner 13 (fs13) / test px_grid_stb
when(isDir("/home/mseminario2/chips/castalia/ic/.simulation/castalia/tb_anatop_pixel/maestro/results/maestro/Interactive.20/13/PotTiaTB/psf")
  openResults("/home/mseminario2/chips/castalia/ic/.simulation/castalia/tb_anatop_pixel/maestro/results/maestro/Interactive.20/13/PotTiaTB/psf")
  when(member('stb results())
    selectResult('stb)
    mtxP = outfile("/home/mseminario2/vestarv/implementations/asic/castalia/analog/data/raw/px_grid_stb__fs13.meta" "w")
    fprintf(mtxP "sweep %%L\n" car(errset(sweepNames())))
    close(mtxP)
    errset(mtxDump("/home/mseminario2/vestarv/implementations/asic/castalia/analog/data/raw/px_grid_stb__fs13__grid_cdl.csv" VAR("cdl_we")))
    errset(mtxDump("/home/mseminario2/vestarv/implementations/asic/castalia/analog/data/raw/px_grid_stb__fs13__grid_rct.csv" VAR("rct_we")))
    errset(mtxDump("/home/mseminario2/vestarv/implementations/asic/castalia/analog/data/raw/px_grid_stb__fs13__grid_rf.csv" VAR("rf")))
    errset(mtxDump("/home/mseminario2/vestarv/implementations/asic/castalia/analog/data/raw/px_grid_stb__fs13__stb_aol_db.csv" value(dB20(getData("loopGain" ?result "stb")) 1)))
    errset(mtxDump("/home/mseminario2/vestarv/implementations/asic/castalia/analog/data/raw/px_grid_stb__fs13__stb_pm.csv" (phaseMargin(getData("loopGain" ?result "stb")) + 180)))
  )
)

;; ---- corner 14 (sf14) / test px_grid_noise
when(isDir("/home/mseminario2/chips/castalia/ic/.simulation/castalia/tb_anatop_pixel/maestro/results/maestro/Interactive.20/14/PotTiaTB/psf")
  openResults("/home/mseminario2/chips/castalia/ic/.simulation/castalia/tb_anatop_pixel/maestro/results/maestro/Interactive.20/14/PotTiaTB/psf")
  when(member('noise results())
    selectResult('noise)
    mtxP = outfile("/home/mseminario2/vestarv/implementations/asic/castalia/analog/data/raw/px_grid_noise__sf14.meta" "w")
    fprintf(mtxP "sweep %%L\n" car(errset(sweepNames())))
    close(mtxP)
    errset(mtxDump("/home/mseminario2/vestarv/implementations/asic/castalia/analog/data/raw/px_grid_noise__sf14__grid_cdl.csv" VAR("cdl_we")))
    errset(mtxDump("/home/mseminario2/vestarv/implementations/asic/castalia/analog/data/raw/px_grid_noise__sf14__grid_rct.csv" VAR("rct_we")))
    errset(mtxDump("/home/mseminario2/vestarv/implementations/asic/castalia/analog/data/raw/px_grid_noise__sf14__grid_rf.csv" VAR("rf")))
    errset(mtxDump("/home/mseminario2/vestarv/implementations/asic/castalia/analog/data/raw/px_grid_noise__sf14__in_rma.csv" (rmsNoise(0.1 1000.0) / VAR("rf"))))
    errset(mtxDump("/home/mseminario2/vestarv/implementations/asic/castalia/analog/data/raw/px_grid_noise__sf14__vn_out.csv" rmsNoise(0.1 1000.0)))
  )
)

;; ---- corner 14 (sf14) / test px_grid_stb
when(isDir("/home/mseminario2/chips/castalia/ic/.simulation/castalia/tb_anatop_pixel/maestro/results/maestro/Interactive.20/14/PotTiaTB/psf")
  openResults("/home/mseminario2/chips/castalia/ic/.simulation/castalia/tb_anatop_pixel/maestro/results/maestro/Interactive.20/14/PotTiaTB/psf")
  when(member('stb results())
    selectResult('stb)
    mtxP = outfile("/home/mseminario2/vestarv/implementations/asic/castalia/analog/data/raw/px_grid_stb__sf14.meta" "w")
    fprintf(mtxP "sweep %%L\n" car(errset(sweepNames())))
    close(mtxP)
    errset(mtxDump("/home/mseminario2/vestarv/implementations/asic/castalia/analog/data/raw/px_grid_stb__sf14__grid_cdl.csv" VAR("cdl_we")))
    errset(mtxDump("/home/mseminario2/vestarv/implementations/asic/castalia/analog/data/raw/px_grid_stb__sf14__grid_rct.csv" VAR("rct_we")))
    errset(mtxDump("/home/mseminario2/vestarv/implementations/asic/castalia/analog/data/raw/px_grid_stb__sf14__grid_rf.csv" VAR("rf")))
    errset(mtxDump("/home/mseminario2/vestarv/implementations/asic/castalia/analog/data/raw/px_grid_stb__sf14__stb_aol_db.csv" value(dB20(getData("loopGain" ?result "stb")) 1)))
    errset(mtxDump("/home/mseminario2/vestarv/implementations/asic/castalia/analog/data/raw/px_grid_stb__sf14__stb_pm.csv" (phaseMargin(getData("loopGain" ?result "stb")) + 180)))
  )
)

;; ---- corner 15 (ss15) / test px_grid_noise
when(isDir("/home/mseminario2/chips/castalia/ic/.simulation/castalia/tb_anatop_pixel/maestro/results/maestro/Interactive.20/15/PotTiaTB/psf")
  openResults("/home/mseminario2/chips/castalia/ic/.simulation/castalia/tb_anatop_pixel/maestro/results/maestro/Interactive.20/15/PotTiaTB/psf")
  when(member('noise results())
    selectResult('noise)
    mtxP = outfile("/home/mseminario2/vestarv/implementations/asic/castalia/analog/data/raw/px_grid_noise__ss15.meta" "w")
    fprintf(mtxP "sweep %%L\n" car(errset(sweepNames())))
    close(mtxP)
    errset(mtxDump("/home/mseminario2/vestarv/implementations/asic/castalia/analog/data/raw/px_grid_noise__ss15__grid_cdl.csv" VAR("cdl_we")))
    errset(mtxDump("/home/mseminario2/vestarv/implementations/asic/castalia/analog/data/raw/px_grid_noise__ss15__grid_rct.csv" VAR("rct_we")))
    errset(mtxDump("/home/mseminario2/vestarv/implementations/asic/castalia/analog/data/raw/px_grid_noise__ss15__grid_rf.csv" VAR("rf")))
    errset(mtxDump("/home/mseminario2/vestarv/implementations/asic/castalia/analog/data/raw/px_grid_noise__ss15__in_rma.csv" (rmsNoise(0.1 1000.0) / VAR("rf"))))
    errset(mtxDump("/home/mseminario2/vestarv/implementations/asic/castalia/analog/data/raw/px_grid_noise__ss15__vn_out.csv" rmsNoise(0.1 1000.0)))
  )
)

;; ---- corner 15 (ss15) / test px_grid_stb
when(isDir("/home/mseminario2/chips/castalia/ic/.simulation/castalia/tb_anatop_pixel/maestro/results/maestro/Interactive.20/15/PotTiaTB/psf")
  openResults("/home/mseminario2/chips/castalia/ic/.simulation/castalia/tb_anatop_pixel/maestro/results/maestro/Interactive.20/15/PotTiaTB/psf")
  when(member('stb results())
    selectResult('stb)
    mtxP = outfile("/home/mseminario2/vestarv/implementations/asic/castalia/analog/data/raw/px_grid_stb__ss15.meta" "w")
    fprintf(mtxP "sweep %%L\n" car(errset(sweepNames())))
    close(mtxP)
    errset(mtxDump("/home/mseminario2/vestarv/implementations/asic/castalia/analog/data/raw/px_grid_stb__ss15__grid_cdl.csv" VAR("cdl_we")))
    errset(mtxDump("/home/mseminario2/vestarv/implementations/asic/castalia/analog/data/raw/px_grid_stb__ss15__grid_rct.csv" VAR("rct_we")))
    errset(mtxDump("/home/mseminario2/vestarv/implementations/asic/castalia/analog/data/raw/px_grid_stb__ss15__grid_rf.csv" VAR("rf")))
    errset(mtxDump("/home/mseminario2/vestarv/implementations/asic/castalia/analog/data/raw/px_grid_stb__ss15__stb_aol_db.csv" value(dB20(getData("loopGain" ?result "stb")) 1)))
    errset(mtxDump("/home/mseminario2/vestarv/implementations/asic/castalia/analog/data/raw/px_grid_stb__ss15__stb_pm.csv" (phaseMargin(getData("loopGain" ?result "stb")) + 180)))
  )
)

;; ---- corner 16 (pt16) / test px_grid_noise
when(isDir("/home/mseminario2/chips/castalia/ic/.simulation/castalia/tb_anatop_pixel/maestro/results/maestro/Interactive.20/16/PotTiaTB/psf")
  openResults("/home/mseminario2/chips/castalia/ic/.simulation/castalia/tb_anatop_pixel/maestro/results/maestro/Interactive.20/16/PotTiaTB/psf")
  when(member('noise results())
    selectResult('noise)
    mtxP = outfile("/home/mseminario2/vestarv/implementations/asic/castalia/analog/data/raw/px_grid_noise__pt16.meta" "w")
    fprintf(mtxP "sweep %%L\n" car(errset(sweepNames())))
    close(mtxP)
    errset(mtxDump("/home/mseminario2/vestarv/implementations/asic/castalia/analog/data/raw/px_grid_noise__pt16__grid_cdl.csv" VAR("cdl_we")))
    errset(mtxDump("/home/mseminario2/vestarv/implementations/asic/castalia/analog/data/raw/px_grid_noise__pt16__grid_rct.csv" VAR("rct_we")))
    errset(mtxDump("/home/mseminario2/vestarv/implementations/asic/castalia/analog/data/raw/px_grid_noise__pt16__grid_rf.csv" VAR("rf")))
    errset(mtxDump("/home/mseminario2/vestarv/implementations/asic/castalia/analog/data/raw/px_grid_noise__pt16__in_rma.csv" (rmsNoise(0.1 1000.0) / VAR("rf"))))
    errset(mtxDump("/home/mseminario2/vestarv/implementations/asic/castalia/analog/data/raw/px_grid_noise__pt16__vn_out.csv" rmsNoise(0.1 1000.0)))
  )
)

;; ---- corner 16 (pt16) / test px_grid_stb
when(isDir("/home/mseminario2/chips/castalia/ic/.simulation/castalia/tb_anatop_pixel/maestro/results/maestro/Interactive.20/16/PotTiaTB/psf")
  openResults("/home/mseminario2/chips/castalia/ic/.simulation/castalia/tb_anatop_pixel/maestro/results/maestro/Interactive.20/16/PotTiaTB/psf")
  when(member('stb results())
    selectResult('stb)
    mtxP = outfile("/home/mseminario2/vestarv/implementations/asic/castalia/analog/data/raw/px_grid_stb__pt16.meta" "w")
    fprintf(mtxP "sweep %%L\n" car(errset(sweepNames())))
    close(mtxP)
    errset(mtxDump("/home/mseminario2/vestarv/implementations/asic/castalia/analog/data/raw/px_grid_stb__pt16__grid_cdl.csv" VAR("cdl_we")))
    errset(mtxDump("/home/mseminario2/vestarv/implementations/asic/castalia/analog/data/raw/px_grid_stb__pt16__grid_rct.csv" VAR("rct_we")))
    errset(mtxDump("/home/mseminario2/vestarv/implementations/asic/castalia/analog/data/raw/px_grid_stb__pt16__grid_rf.csv" VAR("rf")))
    errset(mtxDump("/home/mseminario2/vestarv/implementations/asic/castalia/analog/data/raw/px_grid_stb__pt16__stb_aol_db.csv" value(dB20(getData("loopGain" ?result "stb")) 1)))
    errset(mtxDump("/home/mseminario2/vestarv/implementations/asic/castalia/analog/data/raw/px_grid_stb__pt16__stb_pm.csv" (phaseMargin(getData("loopGain" ?result "stb")) + 180)))
  )
)

;; ---- corner 17 (ff17) / test px_grid_noise
when(isDir("/home/mseminario2/chips/castalia/ic/.simulation/castalia/tb_anatop_pixel/maestro/results/maestro/Interactive.20/17/PotTiaTB/psf")
  openResults("/home/mseminario2/chips/castalia/ic/.simulation/castalia/tb_anatop_pixel/maestro/results/maestro/Interactive.20/17/PotTiaTB/psf")
  when(member('noise results())
    selectResult('noise)
    mtxP = outfile("/home/mseminario2/vestarv/implementations/asic/castalia/analog/data/raw/px_grid_noise__ff17.meta" "w")
    fprintf(mtxP "sweep %%L\n" car(errset(sweepNames())))
    close(mtxP)
    errset(mtxDump("/home/mseminario2/vestarv/implementations/asic/castalia/analog/data/raw/px_grid_noise__ff17__grid_cdl.csv" VAR("cdl_we")))
    errset(mtxDump("/home/mseminario2/vestarv/implementations/asic/castalia/analog/data/raw/px_grid_noise__ff17__grid_rct.csv" VAR("rct_we")))
    errset(mtxDump("/home/mseminario2/vestarv/implementations/asic/castalia/analog/data/raw/px_grid_noise__ff17__grid_rf.csv" VAR("rf")))
    errset(mtxDump("/home/mseminario2/vestarv/implementations/asic/castalia/analog/data/raw/px_grid_noise__ff17__in_rma.csv" (rmsNoise(0.1 1000.0) / VAR("rf"))))
    errset(mtxDump("/home/mseminario2/vestarv/implementations/asic/castalia/analog/data/raw/px_grid_noise__ff17__vn_out.csv" rmsNoise(0.1 1000.0)))
  )
)

;; ---- corner 17 (ff17) / test px_grid_stb
when(isDir("/home/mseminario2/chips/castalia/ic/.simulation/castalia/tb_anatop_pixel/maestro/results/maestro/Interactive.20/17/PotTiaTB/psf")
  openResults("/home/mseminario2/chips/castalia/ic/.simulation/castalia/tb_anatop_pixel/maestro/results/maestro/Interactive.20/17/PotTiaTB/psf")
  when(member('stb results())
    selectResult('stb)
    mtxP = outfile("/home/mseminario2/vestarv/implementations/asic/castalia/analog/data/raw/px_grid_stb__ff17.meta" "w")
    fprintf(mtxP "sweep %%L\n" car(errset(sweepNames())))
    close(mtxP)
    errset(mtxDump("/home/mseminario2/vestarv/implementations/asic/castalia/analog/data/raw/px_grid_stb__ff17__grid_cdl.csv" VAR("cdl_we")))
    errset(mtxDump("/home/mseminario2/vestarv/implementations/asic/castalia/analog/data/raw/px_grid_stb__ff17__grid_rct.csv" VAR("rct_we")))
    errset(mtxDump("/home/mseminario2/vestarv/implementations/asic/castalia/analog/data/raw/px_grid_stb__ff17__grid_rf.csv" VAR("rf")))
    errset(mtxDump("/home/mseminario2/vestarv/implementations/asic/castalia/analog/data/raw/px_grid_stb__ff17__stb_aol_db.csv" value(dB20(getData("loopGain" ?result "stb")) 1)))
    errset(mtxDump("/home/mseminario2/vestarv/implementations/asic/castalia/analog/data/raw/px_grid_stb__ff17__stb_pm.csv" (phaseMargin(getData("loopGain" ?result "stb")) + 180)))
  )
)

;; ---- corner 18 (fs18) / test px_grid_noise
when(isDir("/home/mseminario2/chips/castalia/ic/.simulation/castalia/tb_anatop_pixel/maestro/results/maestro/Interactive.20/18/PotTiaTB/psf")
  openResults("/home/mseminario2/chips/castalia/ic/.simulation/castalia/tb_anatop_pixel/maestro/results/maestro/Interactive.20/18/PotTiaTB/psf")
  when(member('noise results())
    selectResult('noise)
    mtxP = outfile("/home/mseminario2/vestarv/implementations/asic/castalia/analog/data/raw/px_grid_noise__fs18.meta" "w")
    fprintf(mtxP "sweep %%L\n" car(errset(sweepNames())))
    close(mtxP)
    errset(mtxDump("/home/mseminario2/vestarv/implementations/asic/castalia/analog/data/raw/px_grid_noise__fs18__grid_cdl.csv" VAR("cdl_we")))
    errset(mtxDump("/home/mseminario2/vestarv/implementations/asic/castalia/analog/data/raw/px_grid_noise__fs18__grid_rct.csv" VAR("rct_we")))
    errset(mtxDump("/home/mseminario2/vestarv/implementations/asic/castalia/analog/data/raw/px_grid_noise__fs18__grid_rf.csv" VAR("rf")))
    errset(mtxDump("/home/mseminario2/vestarv/implementations/asic/castalia/analog/data/raw/px_grid_noise__fs18__in_rma.csv" (rmsNoise(0.1 1000.0) / VAR("rf"))))
    errset(mtxDump("/home/mseminario2/vestarv/implementations/asic/castalia/analog/data/raw/px_grid_noise__fs18__vn_out.csv" rmsNoise(0.1 1000.0)))
  )
)

;; ---- corner 18 (fs18) / test px_grid_stb
when(isDir("/home/mseminario2/chips/castalia/ic/.simulation/castalia/tb_anatop_pixel/maestro/results/maestro/Interactive.20/18/PotTiaTB/psf")
  openResults("/home/mseminario2/chips/castalia/ic/.simulation/castalia/tb_anatop_pixel/maestro/results/maestro/Interactive.20/18/PotTiaTB/psf")
  when(member('stb results())
    selectResult('stb)
    mtxP = outfile("/home/mseminario2/vestarv/implementations/asic/castalia/analog/data/raw/px_grid_stb__fs18.meta" "w")
    fprintf(mtxP "sweep %%L\n" car(errset(sweepNames())))
    close(mtxP)
    errset(mtxDump("/home/mseminario2/vestarv/implementations/asic/castalia/analog/data/raw/px_grid_stb__fs18__grid_cdl.csv" VAR("cdl_we")))
    errset(mtxDump("/home/mseminario2/vestarv/implementations/asic/castalia/analog/data/raw/px_grid_stb__fs18__grid_rct.csv" VAR("rct_we")))
    errset(mtxDump("/home/mseminario2/vestarv/implementations/asic/castalia/analog/data/raw/px_grid_stb__fs18__grid_rf.csv" VAR("rf")))
    errset(mtxDump("/home/mseminario2/vestarv/implementations/asic/castalia/analog/data/raw/px_grid_stb__fs18__stb_aol_db.csv" value(dB20(getData("loopGain" ?result "stb")) 1)))
    errset(mtxDump("/home/mseminario2/vestarv/implementations/asic/castalia/analog/data/raw/px_grid_stb__fs18__stb_pm.csv" (phaseMargin(getData("loopGain" ?result "stb")) + 180)))
  )
)

;; ---- corner 19 (sf19) / test px_grid_noise
when(isDir("/home/mseminario2/chips/castalia/ic/.simulation/castalia/tb_anatop_pixel/maestro/results/maestro/Interactive.20/19/PotTiaTB/psf")
  openResults("/home/mseminario2/chips/castalia/ic/.simulation/castalia/tb_anatop_pixel/maestro/results/maestro/Interactive.20/19/PotTiaTB/psf")
  when(member('noise results())
    selectResult('noise)
    mtxP = outfile("/home/mseminario2/vestarv/implementations/asic/castalia/analog/data/raw/px_grid_noise__sf19.meta" "w")
    fprintf(mtxP "sweep %%L\n" car(errset(sweepNames())))
    close(mtxP)
    errset(mtxDump("/home/mseminario2/vestarv/implementations/asic/castalia/analog/data/raw/px_grid_noise__sf19__grid_cdl.csv" VAR("cdl_we")))
    errset(mtxDump("/home/mseminario2/vestarv/implementations/asic/castalia/analog/data/raw/px_grid_noise__sf19__grid_rct.csv" VAR("rct_we")))
    errset(mtxDump("/home/mseminario2/vestarv/implementations/asic/castalia/analog/data/raw/px_grid_noise__sf19__grid_rf.csv" VAR("rf")))
    errset(mtxDump("/home/mseminario2/vestarv/implementations/asic/castalia/analog/data/raw/px_grid_noise__sf19__in_rma.csv" (rmsNoise(0.1 1000.0) / VAR("rf"))))
    errset(mtxDump("/home/mseminario2/vestarv/implementations/asic/castalia/analog/data/raw/px_grid_noise__sf19__vn_out.csv" rmsNoise(0.1 1000.0)))
  )
)

;; ---- corner 19 (sf19) / test px_grid_stb
when(isDir("/home/mseminario2/chips/castalia/ic/.simulation/castalia/tb_anatop_pixel/maestro/results/maestro/Interactive.20/19/PotTiaTB/psf")
  openResults("/home/mseminario2/chips/castalia/ic/.simulation/castalia/tb_anatop_pixel/maestro/results/maestro/Interactive.20/19/PotTiaTB/psf")
  when(member('stb results())
    selectResult('stb)
    mtxP = outfile("/home/mseminario2/vestarv/implementations/asic/castalia/analog/data/raw/px_grid_stb__sf19.meta" "w")
    fprintf(mtxP "sweep %%L\n" car(errset(sweepNames())))
    close(mtxP)
    errset(mtxDump("/home/mseminario2/vestarv/implementations/asic/castalia/analog/data/raw/px_grid_stb__sf19__grid_cdl.csv" VAR("cdl_we")))
    errset(mtxDump("/home/mseminario2/vestarv/implementations/asic/castalia/analog/data/raw/px_grid_stb__sf19__grid_rct.csv" VAR("rct_we")))
    errset(mtxDump("/home/mseminario2/vestarv/implementations/asic/castalia/analog/data/raw/px_grid_stb__sf19__grid_rf.csv" VAR("rf")))
    errset(mtxDump("/home/mseminario2/vestarv/implementations/asic/castalia/analog/data/raw/px_grid_stb__sf19__stb_aol_db.csv" value(dB20(getData("loopGain" ?result "stb")) 1)))
    errset(mtxDump("/home/mseminario2/vestarv/implementations/asic/castalia/analog/data/raw/px_grid_stb__sf19__stb_pm.csv" (phaseMargin(getData("loopGain" ?result "stb")) + 180)))
  )
)

;; ---- corner 20 (ss20) / test px_grid_noise
when(isDir("/home/mseminario2/chips/castalia/ic/.simulation/castalia/tb_anatop_pixel/maestro/results/maestro/Interactive.20/20/PotTiaTB/psf")
  openResults("/home/mseminario2/chips/castalia/ic/.simulation/castalia/tb_anatop_pixel/maestro/results/maestro/Interactive.20/20/PotTiaTB/psf")
  when(member('noise results())
    selectResult('noise)
    mtxP = outfile("/home/mseminario2/vestarv/implementations/asic/castalia/analog/data/raw/px_grid_noise__ss20.meta" "w")
    fprintf(mtxP "sweep %%L\n" car(errset(sweepNames())))
    close(mtxP)
    errset(mtxDump("/home/mseminario2/vestarv/implementations/asic/castalia/analog/data/raw/px_grid_noise__ss20__grid_cdl.csv" VAR("cdl_we")))
    errset(mtxDump("/home/mseminario2/vestarv/implementations/asic/castalia/analog/data/raw/px_grid_noise__ss20__grid_rct.csv" VAR("rct_we")))
    errset(mtxDump("/home/mseminario2/vestarv/implementations/asic/castalia/analog/data/raw/px_grid_noise__ss20__grid_rf.csv" VAR("rf")))
    errset(mtxDump("/home/mseminario2/vestarv/implementations/asic/castalia/analog/data/raw/px_grid_noise__ss20__in_rma.csv" (rmsNoise(0.1 1000.0) / VAR("rf"))))
    errset(mtxDump("/home/mseminario2/vestarv/implementations/asic/castalia/analog/data/raw/px_grid_noise__ss20__vn_out.csv" rmsNoise(0.1 1000.0)))
  )
)

;; ---- corner 20 (ss20) / test px_grid_stb
when(isDir("/home/mseminario2/chips/castalia/ic/.simulation/castalia/tb_anatop_pixel/maestro/results/maestro/Interactive.20/20/PotTiaTB/psf")
  openResults("/home/mseminario2/chips/castalia/ic/.simulation/castalia/tb_anatop_pixel/maestro/results/maestro/Interactive.20/20/PotTiaTB/psf")
  when(member('stb results())
    selectResult('stb)
    mtxP = outfile("/home/mseminario2/vestarv/implementations/asic/castalia/analog/data/raw/px_grid_stb__ss20.meta" "w")
    fprintf(mtxP "sweep %%L\n" car(errset(sweepNames())))
    close(mtxP)
    errset(mtxDump("/home/mseminario2/vestarv/implementations/asic/castalia/analog/data/raw/px_grid_stb__ss20__grid_cdl.csv" VAR("cdl_we")))
    errset(mtxDump("/home/mseminario2/vestarv/implementations/asic/castalia/analog/data/raw/px_grid_stb__ss20__grid_rct.csv" VAR("rct_we")))
    errset(mtxDump("/home/mseminario2/vestarv/implementations/asic/castalia/analog/data/raw/px_grid_stb__ss20__grid_rf.csv" VAR("rf")))
    errset(mtxDump("/home/mseminario2/vestarv/implementations/asic/castalia/analog/data/raw/px_grid_stb__ss20__stb_aol_db.csv" value(dB20(getData("loopGain" ?result "stb")) 1)))
    errset(mtxDump("/home/mseminario2/vestarv/implementations/asic/castalia/analog/data/raw/px_grid_stb__ss20__stb_pm.csv" (phaseMargin(getData("loopGain" ?result "stb")) + 180)))
  )
)

;; ---- corner 21 (pt21) / test px_grid_noise
when(isDir("/home/mseminario2/chips/castalia/ic/.simulation/castalia/tb_anatop_pixel/maestro/results/maestro/Interactive.20/21/PotTiaTB/psf")
  openResults("/home/mseminario2/chips/castalia/ic/.simulation/castalia/tb_anatop_pixel/maestro/results/maestro/Interactive.20/21/PotTiaTB/psf")
  when(member('noise results())
    selectResult('noise)
    mtxP = outfile("/home/mseminario2/vestarv/implementations/asic/castalia/analog/data/raw/px_grid_noise__pt21.meta" "w")
    fprintf(mtxP "sweep %%L\n" car(errset(sweepNames())))
    close(mtxP)
    errset(mtxDump("/home/mseminario2/vestarv/implementations/asic/castalia/analog/data/raw/px_grid_noise__pt21__grid_cdl.csv" VAR("cdl_we")))
    errset(mtxDump("/home/mseminario2/vestarv/implementations/asic/castalia/analog/data/raw/px_grid_noise__pt21__grid_rct.csv" VAR("rct_we")))
    errset(mtxDump("/home/mseminario2/vestarv/implementations/asic/castalia/analog/data/raw/px_grid_noise__pt21__grid_rf.csv" VAR("rf")))
    errset(mtxDump("/home/mseminario2/vestarv/implementations/asic/castalia/analog/data/raw/px_grid_noise__pt21__in_rma.csv" (rmsNoise(0.1 1000.0) / VAR("rf"))))
    errset(mtxDump("/home/mseminario2/vestarv/implementations/asic/castalia/analog/data/raw/px_grid_noise__pt21__vn_out.csv" rmsNoise(0.1 1000.0)))
  )
)

;; ---- corner 21 (pt21) / test px_grid_stb
when(isDir("/home/mseminario2/chips/castalia/ic/.simulation/castalia/tb_anatop_pixel/maestro/results/maestro/Interactive.20/21/PotTiaTB/psf")
  openResults("/home/mseminario2/chips/castalia/ic/.simulation/castalia/tb_anatop_pixel/maestro/results/maestro/Interactive.20/21/PotTiaTB/psf")
  when(member('stb results())
    selectResult('stb)
    mtxP = outfile("/home/mseminario2/vestarv/implementations/asic/castalia/analog/data/raw/px_grid_stb__pt21.meta" "w")
    fprintf(mtxP "sweep %%L\n" car(errset(sweepNames())))
    close(mtxP)
    errset(mtxDump("/home/mseminario2/vestarv/implementations/asic/castalia/analog/data/raw/px_grid_stb__pt21__grid_cdl.csv" VAR("cdl_we")))
    errset(mtxDump("/home/mseminario2/vestarv/implementations/asic/castalia/analog/data/raw/px_grid_stb__pt21__grid_rct.csv" VAR("rct_we")))
    errset(mtxDump("/home/mseminario2/vestarv/implementations/asic/castalia/analog/data/raw/px_grid_stb__pt21__grid_rf.csv" VAR("rf")))
    errset(mtxDump("/home/mseminario2/vestarv/implementations/asic/castalia/analog/data/raw/px_grid_stb__pt21__stb_aol_db.csv" value(dB20(getData("loopGain" ?result "stb")) 1)))
    errset(mtxDump("/home/mseminario2/vestarv/implementations/asic/castalia/analog/data/raw/px_grid_stb__pt21__stb_pm.csv" (phaseMargin(getData("loopGain" ?result "stb")) + 180)))
  )
)

;; ---- corner 22 (ff22) / test px_grid_noise
when(isDir("/home/mseminario2/chips/castalia/ic/.simulation/castalia/tb_anatop_pixel/maestro/results/maestro/Interactive.20/22/PotTiaTB/psf")
  openResults("/home/mseminario2/chips/castalia/ic/.simulation/castalia/tb_anatop_pixel/maestro/results/maestro/Interactive.20/22/PotTiaTB/psf")
  when(member('noise results())
    selectResult('noise)
    mtxP = outfile("/home/mseminario2/vestarv/implementations/asic/castalia/analog/data/raw/px_grid_noise__ff22.meta" "w")
    fprintf(mtxP "sweep %%L\n" car(errset(sweepNames())))
    close(mtxP)
    errset(mtxDump("/home/mseminario2/vestarv/implementations/asic/castalia/analog/data/raw/px_grid_noise__ff22__grid_cdl.csv" VAR("cdl_we")))
    errset(mtxDump("/home/mseminario2/vestarv/implementations/asic/castalia/analog/data/raw/px_grid_noise__ff22__grid_rct.csv" VAR("rct_we")))
    errset(mtxDump("/home/mseminario2/vestarv/implementations/asic/castalia/analog/data/raw/px_grid_noise__ff22__grid_rf.csv" VAR("rf")))
    errset(mtxDump("/home/mseminario2/vestarv/implementations/asic/castalia/analog/data/raw/px_grid_noise__ff22__in_rma.csv" (rmsNoise(0.1 1000.0) / VAR("rf"))))
    errset(mtxDump("/home/mseminario2/vestarv/implementations/asic/castalia/analog/data/raw/px_grid_noise__ff22__vn_out.csv" rmsNoise(0.1 1000.0)))
  )
)

;; ---- corner 22 (ff22) / test px_grid_stb
when(isDir("/home/mseminario2/chips/castalia/ic/.simulation/castalia/tb_anatop_pixel/maestro/results/maestro/Interactive.20/22/PotTiaTB/psf")
  openResults("/home/mseminario2/chips/castalia/ic/.simulation/castalia/tb_anatop_pixel/maestro/results/maestro/Interactive.20/22/PotTiaTB/psf")
  when(member('stb results())
    selectResult('stb)
    mtxP = outfile("/home/mseminario2/vestarv/implementations/asic/castalia/analog/data/raw/px_grid_stb__ff22.meta" "w")
    fprintf(mtxP "sweep %%L\n" car(errset(sweepNames())))
    close(mtxP)
    errset(mtxDump("/home/mseminario2/vestarv/implementations/asic/castalia/analog/data/raw/px_grid_stb__ff22__grid_cdl.csv" VAR("cdl_we")))
    errset(mtxDump("/home/mseminario2/vestarv/implementations/asic/castalia/analog/data/raw/px_grid_stb__ff22__grid_rct.csv" VAR("rct_we")))
    errset(mtxDump("/home/mseminario2/vestarv/implementations/asic/castalia/analog/data/raw/px_grid_stb__ff22__grid_rf.csv" VAR("rf")))
    errset(mtxDump("/home/mseminario2/vestarv/implementations/asic/castalia/analog/data/raw/px_grid_stb__ff22__stb_aol_db.csv" value(dB20(getData("loopGain" ?result "stb")) 1)))
    errset(mtxDump("/home/mseminario2/vestarv/implementations/asic/castalia/analog/data/raw/px_grid_stb__ff22__stb_pm.csv" (phaseMargin(getData("loopGain" ?result "stb")) + 180)))
  )
)

;; ---- corner 23 (fs23) / test px_grid_noise
when(isDir("/home/mseminario2/chips/castalia/ic/.simulation/castalia/tb_anatop_pixel/maestro/results/maestro/Interactive.20/23/PotTiaTB/psf")
  openResults("/home/mseminario2/chips/castalia/ic/.simulation/castalia/tb_anatop_pixel/maestro/results/maestro/Interactive.20/23/PotTiaTB/psf")
  when(member('noise results())
    selectResult('noise)
    mtxP = outfile("/home/mseminario2/vestarv/implementations/asic/castalia/analog/data/raw/px_grid_noise__fs23.meta" "w")
    fprintf(mtxP "sweep %%L\n" car(errset(sweepNames())))
    close(mtxP)
    errset(mtxDump("/home/mseminario2/vestarv/implementations/asic/castalia/analog/data/raw/px_grid_noise__fs23__grid_cdl.csv" VAR("cdl_we")))
    errset(mtxDump("/home/mseminario2/vestarv/implementations/asic/castalia/analog/data/raw/px_grid_noise__fs23__grid_rct.csv" VAR("rct_we")))
    errset(mtxDump("/home/mseminario2/vestarv/implementations/asic/castalia/analog/data/raw/px_grid_noise__fs23__grid_rf.csv" VAR("rf")))
    errset(mtxDump("/home/mseminario2/vestarv/implementations/asic/castalia/analog/data/raw/px_grid_noise__fs23__in_rma.csv" (rmsNoise(0.1 1000.0) / VAR("rf"))))
    errset(mtxDump("/home/mseminario2/vestarv/implementations/asic/castalia/analog/data/raw/px_grid_noise__fs23__vn_out.csv" rmsNoise(0.1 1000.0)))
  )
)

;; ---- corner 23 (fs23) / test px_grid_stb
when(isDir("/home/mseminario2/chips/castalia/ic/.simulation/castalia/tb_anatop_pixel/maestro/results/maestro/Interactive.20/23/PotTiaTB/psf")
  openResults("/home/mseminario2/chips/castalia/ic/.simulation/castalia/tb_anatop_pixel/maestro/results/maestro/Interactive.20/23/PotTiaTB/psf")
  when(member('stb results())
    selectResult('stb)
    mtxP = outfile("/home/mseminario2/vestarv/implementations/asic/castalia/analog/data/raw/px_grid_stb__fs23.meta" "w")
    fprintf(mtxP "sweep %%L\n" car(errset(sweepNames())))
    close(mtxP)
    errset(mtxDump("/home/mseminario2/vestarv/implementations/asic/castalia/analog/data/raw/px_grid_stb__fs23__grid_cdl.csv" VAR("cdl_we")))
    errset(mtxDump("/home/mseminario2/vestarv/implementations/asic/castalia/analog/data/raw/px_grid_stb__fs23__grid_rct.csv" VAR("rct_we")))
    errset(mtxDump("/home/mseminario2/vestarv/implementations/asic/castalia/analog/data/raw/px_grid_stb__fs23__grid_rf.csv" VAR("rf")))
    errset(mtxDump("/home/mseminario2/vestarv/implementations/asic/castalia/analog/data/raw/px_grid_stb__fs23__stb_aol_db.csv" value(dB20(getData("loopGain" ?result "stb")) 1)))
    errset(mtxDump("/home/mseminario2/vestarv/implementations/asic/castalia/analog/data/raw/px_grid_stb__fs23__stb_pm.csv" (phaseMargin(getData("loopGain" ?result "stb")) + 180)))
  )
)

;; ---- corner 24 (sf24) / test px_grid_noise
when(isDir("/home/mseminario2/chips/castalia/ic/.simulation/castalia/tb_anatop_pixel/maestro/results/maestro/Interactive.20/24/PotTiaTB/psf")
  openResults("/home/mseminario2/chips/castalia/ic/.simulation/castalia/tb_anatop_pixel/maestro/results/maestro/Interactive.20/24/PotTiaTB/psf")
  when(member('noise results())
    selectResult('noise)
    mtxP = outfile("/home/mseminario2/vestarv/implementations/asic/castalia/analog/data/raw/px_grid_noise__sf24.meta" "w")
    fprintf(mtxP "sweep %%L\n" car(errset(sweepNames())))
    close(mtxP)
    errset(mtxDump("/home/mseminario2/vestarv/implementations/asic/castalia/analog/data/raw/px_grid_noise__sf24__grid_cdl.csv" VAR("cdl_we")))
    errset(mtxDump("/home/mseminario2/vestarv/implementations/asic/castalia/analog/data/raw/px_grid_noise__sf24__grid_rct.csv" VAR("rct_we")))
    errset(mtxDump("/home/mseminario2/vestarv/implementations/asic/castalia/analog/data/raw/px_grid_noise__sf24__grid_rf.csv" VAR("rf")))
    errset(mtxDump("/home/mseminario2/vestarv/implementations/asic/castalia/analog/data/raw/px_grid_noise__sf24__in_rma.csv" (rmsNoise(0.1 1000.0) / VAR("rf"))))
    errset(mtxDump("/home/mseminario2/vestarv/implementations/asic/castalia/analog/data/raw/px_grid_noise__sf24__vn_out.csv" rmsNoise(0.1 1000.0)))
  )
)

;; ---- corner 24 (sf24) / test px_grid_stb
when(isDir("/home/mseminario2/chips/castalia/ic/.simulation/castalia/tb_anatop_pixel/maestro/results/maestro/Interactive.20/24/PotTiaTB/psf")
  openResults("/home/mseminario2/chips/castalia/ic/.simulation/castalia/tb_anatop_pixel/maestro/results/maestro/Interactive.20/24/PotTiaTB/psf")
  when(member('stb results())
    selectResult('stb)
    mtxP = outfile("/home/mseminario2/vestarv/implementations/asic/castalia/analog/data/raw/px_grid_stb__sf24.meta" "w")
    fprintf(mtxP "sweep %%L\n" car(errset(sweepNames())))
    close(mtxP)
    errset(mtxDump("/home/mseminario2/vestarv/implementations/asic/castalia/analog/data/raw/px_grid_stb__sf24__grid_cdl.csv" VAR("cdl_we")))
    errset(mtxDump("/home/mseminario2/vestarv/implementations/asic/castalia/analog/data/raw/px_grid_stb__sf24__grid_rct.csv" VAR("rct_we")))
    errset(mtxDump("/home/mseminario2/vestarv/implementations/asic/castalia/analog/data/raw/px_grid_stb__sf24__grid_rf.csv" VAR("rf")))
    errset(mtxDump("/home/mseminario2/vestarv/implementations/asic/castalia/analog/data/raw/px_grid_stb__sf24__stb_aol_db.csv" value(dB20(getData("loopGain" ?result "stb")) 1)))
    errset(mtxDump("/home/mseminario2/vestarv/implementations/asic/castalia/analog/data/raw/px_grid_stb__sf24__stb_pm.csv" (phaseMargin(getData("loopGain" ?result "stb")) + 180)))
  )
)

;; ---- corner 25 (ss25) / test px_grid_noise
when(isDir("/home/mseminario2/chips/castalia/ic/.simulation/castalia/tb_anatop_pixel/maestro/results/maestro/Interactive.20/25/PotTiaTB/psf")
  openResults("/home/mseminario2/chips/castalia/ic/.simulation/castalia/tb_anatop_pixel/maestro/results/maestro/Interactive.20/25/PotTiaTB/psf")
  when(member('noise results())
    selectResult('noise)
    mtxP = outfile("/home/mseminario2/vestarv/implementations/asic/castalia/analog/data/raw/px_grid_noise__ss25.meta" "w")
    fprintf(mtxP "sweep %%L\n" car(errset(sweepNames())))
    close(mtxP)
    errset(mtxDump("/home/mseminario2/vestarv/implementations/asic/castalia/analog/data/raw/px_grid_noise__ss25__grid_cdl.csv" VAR("cdl_we")))
    errset(mtxDump("/home/mseminario2/vestarv/implementations/asic/castalia/analog/data/raw/px_grid_noise__ss25__grid_rct.csv" VAR("rct_we")))
    errset(mtxDump("/home/mseminario2/vestarv/implementations/asic/castalia/analog/data/raw/px_grid_noise__ss25__grid_rf.csv" VAR("rf")))
    errset(mtxDump("/home/mseminario2/vestarv/implementations/asic/castalia/analog/data/raw/px_grid_noise__ss25__in_rma.csv" (rmsNoise(0.1 1000.0) / VAR("rf"))))
    errset(mtxDump("/home/mseminario2/vestarv/implementations/asic/castalia/analog/data/raw/px_grid_noise__ss25__vn_out.csv" rmsNoise(0.1 1000.0)))
  )
)

;; ---- corner 25 (ss25) / test px_grid_stb
when(isDir("/home/mseminario2/chips/castalia/ic/.simulation/castalia/tb_anatop_pixel/maestro/results/maestro/Interactive.20/25/PotTiaTB/psf")
  openResults("/home/mseminario2/chips/castalia/ic/.simulation/castalia/tb_anatop_pixel/maestro/results/maestro/Interactive.20/25/PotTiaTB/psf")
  when(member('stb results())
    selectResult('stb)
    mtxP = outfile("/home/mseminario2/vestarv/implementations/asic/castalia/analog/data/raw/px_grid_stb__ss25.meta" "w")
    fprintf(mtxP "sweep %%L\n" car(errset(sweepNames())))
    close(mtxP)
    errset(mtxDump("/home/mseminario2/vestarv/implementations/asic/castalia/analog/data/raw/px_grid_stb__ss25__grid_cdl.csv" VAR("cdl_we")))
    errset(mtxDump("/home/mseminario2/vestarv/implementations/asic/castalia/analog/data/raw/px_grid_stb__ss25__grid_rct.csv" VAR("rct_we")))
    errset(mtxDump("/home/mseminario2/vestarv/implementations/asic/castalia/analog/data/raw/px_grid_stb__ss25__grid_rf.csv" VAR("rf")))
    errset(mtxDump("/home/mseminario2/vestarv/implementations/asic/castalia/analog/data/raw/px_grid_stb__ss25__stb_aol_db.csv" value(dB20(getData("loopGain" ?result "stb")) 1)))
    errset(mtxDump("/home/mseminario2/vestarv/implementations/asic/castalia/analog/data/raw/px_grid_stb__ss25__stb_pm.csv" (phaseMargin(getData("loopGain" ?result "stb")) + 180)))
  )
)

;; ---- corner 26 (pt26) / test px_grid_noise
when(isDir("/home/mseminario2/chips/castalia/ic/.simulation/castalia/tb_anatop_pixel/maestro/results/maestro/Interactive.20/26/PotTiaTB/psf")
  openResults("/home/mseminario2/chips/castalia/ic/.simulation/castalia/tb_anatop_pixel/maestro/results/maestro/Interactive.20/26/PotTiaTB/psf")
  when(member('noise results())
    selectResult('noise)
    mtxP = outfile("/home/mseminario2/vestarv/implementations/asic/castalia/analog/data/raw/px_grid_noise__pt26.meta" "w")
    fprintf(mtxP "sweep %%L\n" car(errset(sweepNames())))
    close(mtxP)
    errset(mtxDump("/home/mseminario2/vestarv/implementations/asic/castalia/analog/data/raw/px_grid_noise__pt26__grid_cdl.csv" VAR("cdl_we")))
    errset(mtxDump("/home/mseminario2/vestarv/implementations/asic/castalia/analog/data/raw/px_grid_noise__pt26__grid_rct.csv" VAR("rct_we")))
    errset(mtxDump("/home/mseminario2/vestarv/implementations/asic/castalia/analog/data/raw/px_grid_noise__pt26__grid_rf.csv" VAR("rf")))
    errset(mtxDump("/home/mseminario2/vestarv/implementations/asic/castalia/analog/data/raw/px_grid_noise__pt26__in_rma.csv" (rmsNoise(0.1 1000.0) / VAR("rf"))))
    errset(mtxDump("/home/mseminario2/vestarv/implementations/asic/castalia/analog/data/raw/px_grid_noise__pt26__vn_out.csv" rmsNoise(0.1 1000.0)))
  )
)

;; ---- corner 26 (pt26) / test px_grid_stb
when(isDir("/home/mseminario2/chips/castalia/ic/.simulation/castalia/tb_anatop_pixel/maestro/results/maestro/Interactive.20/26/PotTiaTB/psf")
  openResults("/home/mseminario2/chips/castalia/ic/.simulation/castalia/tb_anatop_pixel/maestro/results/maestro/Interactive.20/26/PotTiaTB/psf")
  when(member('stb results())
    selectResult('stb)
    mtxP = outfile("/home/mseminario2/vestarv/implementations/asic/castalia/analog/data/raw/px_grid_stb__pt26.meta" "w")
    fprintf(mtxP "sweep %%L\n" car(errset(sweepNames())))
    close(mtxP)
    errset(mtxDump("/home/mseminario2/vestarv/implementations/asic/castalia/analog/data/raw/px_grid_stb__pt26__grid_cdl.csv" VAR("cdl_we")))
    errset(mtxDump("/home/mseminario2/vestarv/implementations/asic/castalia/analog/data/raw/px_grid_stb__pt26__grid_rct.csv" VAR("rct_we")))
    errset(mtxDump("/home/mseminario2/vestarv/implementations/asic/castalia/analog/data/raw/px_grid_stb__pt26__grid_rf.csv" VAR("rf")))
    errset(mtxDump("/home/mseminario2/vestarv/implementations/asic/castalia/analog/data/raw/px_grid_stb__pt26__stb_aol_db.csv" value(dB20(getData("loopGain" ?result "stb")) 1)))
    errset(mtxDump("/home/mseminario2/vestarv/implementations/asic/castalia/analog/data/raw/px_grid_stb__pt26__stb_pm.csv" (phaseMargin(getData("loopGain" ?result "stb")) + 180)))
  )
)

;; ---- corner 27 (ff27) / test px_grid_noise
when(isDir("/home/mseminario2/chips/castalia/ic/.simulation/castalia/tb_anatop_pixel/maestro/results/maestro/Interactive.20/27/PotTiaTB/psf")
  openResults("/home/mseminario2/chips/castalia/ic/.simulation/castalia/tb_anatop_pixel/maestro/results/maestro/Interactive.20/27/PotTiaTB/psf")
  when(member('noise results())
    selectResult('noise)
    mtxP = outfile("/home/mseminario2/vestarv/implementations/asic/castalia/analog/data/raw/px_grid_noise__ff27.meta" "w")
    fprintf(mtxP "sweep %%L\n" car(errset(sweepNames())))
    close(mtxP)
    errset(mtxDump("/home/mseminario2/vestarv/implementations/asic/castalia/analog/data/raw/px_grid_noise__ff27__grid_cdl.csv" VAR("cdl_we")))
    errset(mtxDump("/home/mseminario2/vestarv/implementations/asic/castalia/analog/data/raw/px_grid_noise__ff27__grid_rct.csv" VAR("rct_we")))
    errset(mtxDump("/home/mseminario2/vestarv/implementations/asic/castalia/analog/data/raw/px_grid_noise__ff27__grid_rf.csv" VAR("rf")))
    errset(mtxDump("/home/mseminario2/vestarv/implementations/asic/castalia/analog/data/raw/px_grid_noise__ff27__in_rma.csv" (rmsNoise(0.1 1000.0) / VAR("rf"))))
    errset(mtxDump("/home/mseminario2/vestarv/implementations/asic/castalia/analog/data/raw/px_grid_noise__ff27__vn_out.csv" rmsNoise(0.1 1000.0)))
  )
)

;; ---- corner 27 (ff27) / test px_grid_stb
when(isDir("/home/mseminario2/chips/castalia/ic/.simulation/castalia/tb_anatop_pixel/maestro/results/maestro/Interactive.20/27/PotTiaTB/psf")
  openResults("/home/mseminario2/chips/castalia/ic/.simulation/castalia/tb_anatop_pixel/maestro/results/maestro/Interactive.20/27/PotTiaTB/psf")
  when(member('stb results())
    selectResult('stb)
    mtxP = outfile("/home/mseminario2/vestarv/implementations/asic/castalia/analog/data/raw/px_grid_stb__ff27.meta" "w")
    fprintf(mtxP "sweep %%L\n" car(errset(sweepNames())))
    close(mtxP)
    errset(mtxDump("/home/mseminario2/vestarv/implementations/asic/castalia/analog/data/raw/px_grid_stb__ff27__grid_cdl.csv" VAR("cdl_we")))
    errset(mtxDump("/home/mseminario2/vestarv/implementations/asic/castalia/analog/data/raw/px_grid_stb__ff27__grid_rct.csv" VAR("rct_we")))
    errset(mtxDump("/home/mseminario2/vestarv/implementations/asic/castalia/analog/data/raw/px_grid_stb__ff27__grid_rf.csv" VAR("rf")))
    errset(mtxDump("/home/mseminario2/vestarv/implementations/asic/castalia/analog/data/raw/px_grid_stb__ff27__stb_aol_db.csv" value(dB20(getData("loopGain" ?result "stb")) 1)))
    errset(mtxDump("/home/mseminario2/vestarv/implementations/asic/castalia/analog/data/raw/px_grid_stb__ff27__stb_pm.csv" (phaseMargin(getData("loopGain" ?result "stb")) + 180)))
  )
)

;; ---- corner 28 (fs28) / test px_grid_noise
when(isDir("/home/mseminario2/chips/castalia/ic/.simulation/castalia/tb_anatop_pixel/maestro/results/maestro/Interactive.20/28/PotTiaTB/psf")
  openResults("/home/mseminario2/chips/castalia/ic/.simulation/castalia/tb_anatop_pixel/maestro/results/maestro/Interactive.20/28/PotTiaTB/psf")
  when(member('noise results())
    selectResult('noise)
    mtxP = outfile("/home/mseminario2/vestarv/implementations/asic/castalia/analog/data/raw/px_grid_noise__fs28.meta" "w")
    fprintf(mtxP "sweep %%L\n" car(errset(sweepNames())))
    close(mtxP)
    errset(mtxDump("/home/mseminario2/vestarv/implementations/asic/castalia/analog/data/raw/px_grid_noise__fs28__grid_cdl.csv" VAR("cdl_we")))
    errset(mtxDump("/home/mseminario2/vestarv/implementations/asic/castalia/analog/data/raw/px_grid_noise__fs28__grid_rct.csv" VAR("rct_we")))
    errset(mtxDump("/home/mseminario2/vestarv/implementations/asic/castalia/analog/data/raw/px_grid_noise__fs28__grid_rf.csv" VAR("rf")))
    errset(mtxDump("/home/mseminario2/vestarv/implementations/asic/castalia/analog/data/raw/px_grid_noise__fs28__in_rma.csv" (rmsNoise(0.1 1000.0) / VAR("rf"))))
    errset(mtxDump("/home/mseminario2/vestarv/implementations/asic/castalia/analog/data/raw/px_grid_noise__fs28__vn_out.csv" rmsNoise(0.1 1000.0)))
  )
)

;; ---- corner 28 (fs28) / test px_grid_stb
when(isDir("/home/mseminario2/chips/castalia/ic/.simulation/castalia/tb_anatop_pixel/maestro/results/maestro/Interactive.20/28/PotTiaTB/psf")
  openResults("/home/mseminario2/chips/castalia/ic/.simulation/castalia/tb_anatop_pixel/maestro/results/maestro/Interactive.20/28/PotTiaTB/psf")
  when(member('stb results())
    selectResult('stb)
    mtxP = outfile("/home/mseminario2/vestarv/implementations/asic/castalia/analog/data/raw/px_grid_stb__fs28.meta" "w")
    fprintf(mtxP "sweep %%L\n" car(errset(sweepNames())))
    close(mtxP)
    errset(mtxDump("/home/mseminario2/vestarv/implementations/asic/castalia/analog/data/raw/px_grid_stb__fs28__grid_cdl.csv" VAR("cdl_we")))
    errset(mtxDump("/home/mseminario2/vestarv/implementations/asic/castalia/analog/data/raw/px_grid_stb__fs28__grid_rct.csv" VAR("rct_we")))
    errset(mtxDump("/home/mseminario2/vestarv/implementations/asic/castalia/analog/data/raw/px_grid_stb__fs28__grid_rf.csv" VAR("rf")))
    errset(mtxDump("/home/mseminario2/vestarv/implementations/asic/castalia/analog/data/raw/px_grid_stb__fs28__stb_aol_db.csv" value(dB20(getData("loopGain" ?result "stb")) 1)))
    errset(mtxDump("/home/mseminario2/vestarv/implementations/asic/castalia/analog/data/raw/px_grid_stb__fs28__stb_pm.csv" (phaseMargin(getData("loopGain" ?result "stb")) + 180)))
  )
)

;; ---- corner 29 (sf29) / test px_grid_noise
when(isDir("/home/mseminario2/chips/castalia/ic/.simulation/castalia/tb_anatop_pixel/maestro/results/maestro/Interactive.20/29/PotTiaTB/psf")
  openResults("/home/mseminario2/chips/castalia/ic/.simulation/castalia/tb_anatop_pixel/maestro/results/maestro/Interactive.20/29/PotTiaTB/psf")
  when(member('noise results())
    selectResult('noise)
    mtxP = outfile("/home/mseminario2/vestarv/implementations/asic/castalia/analog/data/raw/px_grid_noise__sf29.meta" "w")
    fprintf(mtxP "sweep %%L\n" car(errset(sweepNames())))
    close(mtxP)
    errset(mtxDump("/home/mseminario2/vestarv/implementations/asic/castalia/analog/data/raw/px_grid_noise__sf29__grid_cdl.csv" VAR("cdl_we")))
    errset(mtxDump("/home/mseminario2/vestarv/implementations/asic/castalia/analog/data/raw/px_grid_noise__sf29__grid_rct.csv" VAR("rct_we")))
    errset(mtxDump("/home/mseminario2/vestarv/implementations/asic/castalia/analog/data/raw/px_grid_noise__sf29__grid_rf.csv" VAR("rf")))
    errset(mtxDump("/home/mseminario2/vestarv/implementations/asic/castalia/analog/data/raw/px_grid_noise__sf29__in_rma.csv" (rmsNoise(0.1 1000.0) / VAR("rf"))))
    errset(mtxDump("/home/mseminario2/vestarv/implementations/asic/castalia/analog/data/raw/px_grid_noise__sf29__vn_out.csv" rmsNoise(0.1 1000.0)))
  )
)

;; ---- corner 29 (sf29) / test px_grid_stb
when(isDir("/home/mseminario2/chips/castalia/ic/.simulation/castalia/tb_anatop_pixel/maestro/results/maestro/Interactive.20/29/PotTiaTB/psf")
  openResults("/home/mseminario2/chips/castalia/ic/.simulation/castalia/tb_anatop_pixel/maestro/results/maestro/Interactive.20/29/PotTiaTB/psf")
  when(member('stb results())
    selectResult('stb)
    mtxP = outfile("/home/mseminario2/vestarv/implementations/asic/castalia/analog/data/raw/px_grid_stb__sf29.meta" "w")
    fprintf(mtxP "sweep %%L\n" car(errset(sweepNames())))
    close(mtxP)
    errset(mtxDump("/home/mseminario2/vestarv/implementations/asic/castalia/analog/data/raw/px_grid_stb__sf29__grid_cdl.csv" VAR("cdl_we")))
    errset(mtxDump("/home/mseminario2/vestarv/implementations/asic/castalia/analog/data/raw/px_grid_stb__sf29__grid_rct.csv" VAR("rct_we")))
    errset(mtxDump("/home/mseminario2/vestarv/implementations/asic/castalia/analog/data/raw/px_grid_stb__sf29__grid_rf.csv" VAR("rf")))
    errset(mtxDump("/home/mseminario2/vestarv/implementations/asic/castalia/analog/data/raw/px_grid_stb__sf29__stb_aol_db.csv" value(dB20(getData("loopGain" ?result "stb")) 1)))
    errset(mtxDump("/home/mseminario2/vestarv/implementations/asic/castalia/analog/data/raw/px_grid_stb__sf29__stb_pm.csv" (phaseMargin(getData("loopGain" ?result "stb")) + 180)))
  )
)

;; ---- corner 30 (ss30) / test px_grid_noise
when(isDir("/home/mseminario2/chips/castalia/ic/.simulation/castalia/tb_anatop_pixel/maestro/results/maestro/Interactive.20/30/PotTiaTB/psf")
  openResults("/home/mseminario2/chips/castalia/ic/.simulation/castalia/tb_anatop_pixel/maestro/results/maestro/Interactive.20/30/PotTiaTB/psf")
  when(member('noise results())
    selectResult('noise)
    mtxP = outfile("/home/mseminario2/vestarv/implementations/asic/castalia/analog/data/raw/px_grid_noise__ss30.meta" "w")
    fprintf(mtxP "sweep %%L\n" car(errset(sweepNames())))
    close(mtxP)
    errset(mtxDump("/home/mseminario2/vestarv/implementations/asic/castalia/analog/data/raw/px_grid_noise__ss30__grid_cdl.csv" VAR("cdl_we")))
    errset(mtxDump("/home/mseminario2/vestarv/implementations/asic/castalia/analog/data/raw/px_grid_noise__ss30__grid_rct.csv" VAR("rct_we")))
    errset(mtxDump("/home/mseminario2/vestarv/implementations/asic/castalia/analog/data/raw/px_grid_noise__ss30__grid_rf.csv" VAR("rf")))
    errset(mtxDump("/home/mseminario2/vestarv/implementations/asic/castalia/analog/data/raw/px_grid_noise__ss30__in_rma.csv" (rmsNoise(0.1 1000.0) / VAR("rf"))))
    errset(mtxDump("/home/mseminario2/vestarv/implementations/asic/castalia/analog/data/raw/px_grid_noise__ss30__vn_out.csv" rmsNoise(0.1 1000.0)))
  )
)

;; ---- corner 30 (ss30) / test px_grid_stb
when(isDir("/home/mseminario2/chips/castalia/ic/.simulation/castalia/tb_anatop_pixel/maestro/results/maestro/Interactive.20/30/PotTiaTB/psf")
  openResults("/home/mseminario2/chips/castalia/ic/.simulation/castalia/tb_anatop_pixel/maestro/results/maestro/Interactive.20/30/PotTiaTB/psf")
  when(member('stb results())
    selectResult('stb)
    mtxP = outfile("/home/mseminario2/vestarv/implementations/asic/castalia/analog/data/raw/px_grid_stb__ss30.meta" "w")
    fprintf(mtxP "sweep %%L\n" car(errset(sweepNames())))
    close(mtxP)
    errset(mtxDump("/home/mseminario2/vestarv/implementations/asic/castalia/analog/data/raw/px_grid_stb__ss30__grid_cdl.csv" VAR("cdl_we")))
    errset(mtxDump("/home/mseminario2/vestarv/implementations/asic/castalia/analog/data/raw/px_grid_stb__ss30__grid_rct.csv" VAR("rct_we")))
    errset(mtxDump("/home/mseminario2/vestarv/implementations/asic/castalia/analog/data/raw/px_grid_stb__ss30__grid_rf.csv" VAR("rf")))
    errset(mtxDump("/home/mseminario2/vestarv/implementations/asic/castalia/analog/data/raw/px_grid_stb__ss30__stb_aol_db.csv" value(dB20(getData("loopGain" ?result "stb")) 1)))
    errset(mtxDump("/home/mseminario2/vestarv/implementations/asic/castalia/analog/data/raw/px_grid_stb__ss30__stb_pm.csv" (phaseMargin(getData("loopGain" ?result "stb")) + 180)))
  )
)

;; ---- corner 31 (pt31) / test px_grid_noise
when(isDir("/home/mseminario2/chips/castalia/ic/.simulation/castalia/tb_anatop_pixel/maestro/results/maestro/Interactive.20/31/PotTiaTB/psf")
  openResults("/home/mseminario2/chips/castalia/ic/.simulation/castalia/tb_anatop_pixel/maestro/results/maestro/Interactive.20/31/PotTiaTB/psf")
  when(member('noise results())
    selectResult('noise)
    mtxP = outfile("/home/mseminario2/vestarv/implementations/asic/castalia/analog/data/raw/px_grid_noise__pt31.meta" "w")
    fprintf(mtxP "sweep %%L\n" car(errset(sweepNames())))
    close(mtxP)
    errset(mtxDump("/home/mseminario2/vestarv/implementations/asic/castalia/analog/data/raw/px_grid_noise__pt31__grid_cdl.csv" VAR("cdl_we")))
    errset(mtxDump("/home/mseminario2/vestarv/implementations/asic/castalia/analog/data/raw/px_grid_noise__pt31__grid_rct.csv" VAR("rct_we")))
    errset(mtxDump("/home/mseminario2/vestarv/implementations/asic/castalia/analog/data/raw/px_grid_noise__pt31__grid_rf.csv" VAR("rf")))
    errset(mtxDump("/home/mseminario2/vestarv/implementations/asic/castalia/analog/data/raw/px_grid_noise__pt31__in_rma.csv" (rmsNoise(0.1 1000.0) / VAR("rf"))))
    errset(mtxDump("/home/mseminario2/vestarv/implementations/asic/castalia/analog/data/raw/px_grid_noise__pt31__vn_out.csv" rmsNoise(0.1 1000.0)))
  )
)

;; ---- corner 31 (pt31) / test px_grid_stb
when(isDir("/home/mseminario2/chips/castalia/ic/.simulation/castalia/tb_anatop_pixel/maestro/results/maestro/Interactive.20/31/PotTiaTB/psf")
  openResults("/home/mseminario2/chips/castalia/ic/.simulation/castalia/tb_anatop_pixel/maestro/results/maestro/Interactive.20/31/PotTiaTB/psf")
  when(member('stb results())
    selectResult('stb)
    mtxP = outfile("/home/mseminario2/vestarv/implementations/asic/castalia/analog/data/raw/px_grid_stb__pt31.meta" "w")
    fprintf(mtxP "sweep %%L\n" car(errset(sweepNames())))
    close(mtxP)
    errset(mtxDump("/home/mseminario2/vestarv/implementations/asic/castalia/analog/data/raw/px_grid_stb__pt31__grid_cdl.csv" VAR("cdl_we")))
    errset(mtxDump("/home/mseminario2/vestarv/implementations/asic/castalia/analog/data/raw/px_grid_stb__pt31__grid_rct.csv" VAR("rct_we")))
    errset(mtxDump("/home/mseminario2/vestarv/implementations/asic/castalia/analog/data/raw/px_grid_stb__pt31__grid_rf.csv" VAR("rf")))
    errset(mtxDump("/home/mseminario2/vestarv/implementations/asic/castalia/analog/data/raw/px_grid_stb__pt31__stb_aol_db.csv" value(dB20(getData("loopGain" ?result "stb")) 1)))
    errset(mtxDump("/home/mseminario2/vestarv/implementations/asic/castalia/analog/data/raw/px_grid_stb__pt31__stb_pm.csv" (phaseMargin(getData("loopGain" ?result "stb")) + 180)))
  )
)

;; ---- corner 32 (ff32) / test px_grid_noise
when(isDir("/home/mseminario2/chips/castalia/ic/.simulation/castalia/tb_anatop_pixel/maestro/results/maestro/Interactive.20/32/PotTiaTB/psf")
  openResults("/home/mseminario2/chips/castalia/ic/.simulation/castalia/tb_anatop_pixel/maestro/results/maestro/Interactive.20/32/PotTiaTB/psf")
  when(member('noise results())
    selectResult('noise)
    mtxP = outfile("/home/mseminario2/vestarv/implementations/asic/castalia/analog/data/raw/px_grid_noise__ff32.meta" "w")
    fprintf(mtxP "sweep %%L\n" car(errset(sweepNames())))
    close(mtxP)
    errset(mtxDump("/home/mseminario2/vestarv/implementations/asic/castalia/analog/data/raw/px_grid_noise__ff32__grid_cdl.csv" VAR("cdl_we")))
    errset(mtxDump("/home/mseminario2/vestarv/implementations/asic/castalia/analog/data/raw/px_grid_noise__ff32__grid_rct.csv" VAR("rct_we")))
    errset(mtxDump("/home/mseminario2/vestarv/implementations/asic/castalia/analog/data/raw/px_grid_noise__ff32__grid_rf.csv" VAR("rf")))
    errset(mtxDump("/home/mseminario2/vestarv/implementations/asic/castalia/analog/data/raw/px_grid_noise__ff32__in_rma.csv" (rmsNoise(0.1 1000.0) / VAR("rf"))))
    errset(mtxDump("/home/mseminario2/vestarv/implementations/asic/castalia/analog/data/raw/px_grid_noise__ff32__vn_out.csv" rmsNoise(0.1 1000.0)))
  )
)

;; ---- corner 32 (ff32) / test px_grid_stb
when(isDir("/home/mseminario2/chips/castalia/ic/.simulation/castalia/tb_anatop_pixel/maestro/results/maestro/Interactive.20/32/PotTiaTB/psf")
  openResults("/home/mseminario2/chips/castalia/ic/.simulation/castalia/tb_anatop_pixel/maestro/results/maestro/Interactive.20/32/PotTiaTB/psf")
  when(member('stb results())
    selectResult('stb)
    mtxP = outfile("/home/mseminario2/vestarv/implementations/asic/castalia/analog/data/raw/px_grid_stb__ff32.meta" "w")
    fprintf(mtxP "sweep %%L\n" car(errset(sweepNames())))
    close(mtxP)
    errset(mtxDump("/home/mseminario2/vestarv/implementations/asic/castalia/analog/data/raw/px_grid_stb__ff32__grid_cdl.csv" VAR("cdl_we")))
    errset(mtxDump("/home/mseminario2/vestarv/implementations/asic/castalia/analog/data/raw/px_grid_stb__ff32__grid_rct.csv" VAR("rct_we")))
    errset(mtxDump("/home/mseminario2/vestarv/implementations/asic/castalia/analog/data/raw/px_grid_stb__ff32__grid_rf.csv" VAR("rf")))
    errset(mtxDump("/home/mseminario2/vestarv/implementations/asic/castalia/analog/data/raw/px_grid_stb__ff32__stb_aol_db.csv" value(dB20(getData("loopGain" ?result "stb")) 1)))
    errset(mtxDump("/home/mseminario2/vestarv/implementations/asic/castalia/analog/data/raw/px_grid_stb__ff32__stb_pm.csv" (phaseMargin(getData("loopGain" ?result "stb")) + 180)))
  )
)

;; ---- corner 33 (fs33) / test px_grid_noise
when(isDir("/home/mseminario2/chips/castalia/ic/.simulation/castalia/tb_anatop_pixel/maestro/results/maestro/Interactive.20/33/PotTiaTB/psf")
  openResults("/home/mseminario2/chips/castalia/ic/.simulation/castalia/tb_anatop_pixel/maestro/results/maestro/Interactive.20/33/PotTiaTB/psf")
  when(member('noise results())
    selectResult('noise)
    mtxP = outfile("/home/mseminario2/vestarv/implementations/asic/castalia/analog/data/raw/px_grid_noise__fs33.meta" "w")
    fprintf(mtxP "sweep %%L\n" car(errset(sweepNames())))
    close(mtxP)
    errset(mtxDump("/home/mseminario2/vestarv/implementations/asic/castalia/analog/data/raw/px_grid_noise__fs33__grid_cdl.csv" VAR("cdl_we")))
    errset(mtxDump("/home/mseminario2/vestarv/implementations/asic/castalia/analog/data/raw/px_grid_noise__fs33__grid_rct.csv" VAR("rct_we")))
    errset(mtxDump("/home/mseminario2/vestarv/implementations/asic/castalia/analog/data/raw/px_grid_noise__fs33__grid_rf.csv" VAR("rf")))
    errset(mtxDump("/home/mseminario2/vestarv/implementations/asic/castalia/analog/data/raw/px_grid_noise__fs33__in_rma.csv" (rmsNoise(0.1 1000.0) / VAR("rf"))))
    errset(mtxDump("/home/mseminario2/vestarv/implementations/asic/castalia/analog/data/raw/px_grid_noise__fs33__vn_out.csv" rmsNoise(0.1 1000.0)))
  )
)

;; ---- corner 33 (fs33) / test px_grid_stb
when(isDir("/home/mseminario2/chips/castalia/ic/.simulation/castalia/tb_anatop_pixel/maestro/results/maestro/Interactive.20/33/PotTiaTB/psf")
  openResults("/home/mseminario2/chips/castalia/ic/.simulation/castalia/tb_anatop_pixel/maestro/results/maestro/Interactive.20/33/PotTiaTB/psf")
  when(member('stb results())
    selectResult('stb)
    mtxP = outfile("/home/mseminario2/vestarv/implementations/asic/castalia/analog/data/raw/px_grid_stb__fs33.meta" "w")
    fprintf(mtxP "sweep %%L\n" car(errset(sweepNames())))
    close(mtxP)
    errset(mtxDump("/home/mseminario2/vestarv/implementations/asic/castalia/analog/data/raw/px_grid_stb__fs33__grid_cdl.csv" VAR("cdl_we")))
    errset(mtxDump("/home/mseminario2/vestarv/implementations/asic/castalia/analog/data/raw/px_grid_stb__fs33__grid_rct.csv" VAR("rct_we")))
    errset(mtxDump("/home/mseminario2/vestarv/implementations/asic/castalia/analog/data/raw/px_grid_stb__fs33__grid_rf.csv" VAR("rf")))
    errset(mtxDump("/home/mseminario2/vestarv/implementations/asic/castalia/analog/data/raw/px_grid_stb__fs33__stb_aol_db.csv" value(dB20(getData("loopGain" ?result "stb")) 1)))
    errset(mtxDump("/home/mseminario2/vestarv/implementations/asic/castalia/analog/data/raw/px_grid_stb__fs33__stb_pm.csv" (phaseMargin(getData("loopGain" ?result "stb")) + 180)))
  )
)

;; ---- corner 34 (sf34) / test px_grid_noise
when(isDir("/home/mseminario2/chips/castalia/ic/.simulation/castalia/tb_anatop_pixel/maestro/results/maestro/Interactive.20/34/PotTiaTB/psf")
  openResults("/home/mseminario2/chips/castalia/ic/.simulation/castalia/tb_anatop_pixel/maestro/results/maestro/Interactive.20/34/PotTiaTB/psf")
  when(member('noise results())
    selectResult('noise)
    mtxP = outfile("/home/mseminario2/vestarv/implementations/asic/castalia/analog/data/raw/px_grid_noise__sf34.meta" "w")
    fprintf(mtxP "sweep %%L\n" car(errset(sweepNames())))
    close(mtxP)
    errset(mtxDump("/home/mseminario2/vestarv/implementations/asic/castalia/analog/data/raw/px_grid_noise__sf34__grid_cdl.csv" VAR("cdl_we")))
    errset(mtxDump("/home/mseminario2/vestarv/implementations/asic/castalia/analog/data/raw/px_grid_noise__sf34__grid_rct.csv" VAR("rct_we")))
    errset(mtxDump("/home/mseminario2/vestarv/implementations/asic/castalia/analog/data/raw/px_grid_noise__sf34__grid_rf.csv" VAR("rf")))
    errset(mtxDump("/home/mseminario2/vestarv/implementations/asic/castalia/analog/data/raw/px_grid_noise__sf34__in_rma.csv" (rmsNoise(0.1 1000.0) / VAR("rf"))))
    errset(mtxDump("/home/mseminario2/vestarv/implementations/asic/castalia/analog/data/raw/px_grid_noise__sf34__vn_out.csv" rmsNoise(0.1 1000.0)))
  )
)

;; ---- corner 34 (sf34) / test px_grid_stb
when(isDir("/home/mseminario2/chips/castalia/ic/.simulation/castalia/tb_anatop_pixel/maestro/results/maestro/Interactive.20/34/PotTiaTB/psf")
  openResults("/home/mseminario2/chips/castalia/ic/.simulation/castalia/tb_anatop_pixel/maestro/results/maestro/Interactive.20/34/PotTiaTB/psf")
  when(member('stb results())
    selectResult('stb)
    mtxP = outfile("/home/mseminario2/vestarv/implementations/asic/castalia/analog/data/raw/px_grid_stb__sf34.meta" "w")
    fprintf(mtxP "sweep %%L\n" car(errset(sweepNames())))
    close(mtxP)
    errset(mtxDump("/home/mseminario2/vestarv/implementations/asic/castalia/analog/data/raw/px_grid_stb__sf34__grid_cdl.csv" VAR("cdl_we")))
    errset(mtxDump("/home/mseminario2/vestarv/implementations/asic/castalia/analog/data/raw/px_grid_stb__sf34__grid_rct.csv" VAR("rct_we")))
    errset(mtxDump("/home/mseminario2/vestarv/implementations/asic/castalia/analog/data/raw/px_grid_stb__sf34__grid_rf.csv" VAR("rf")))
    errset(mtxDump("/home/mseminario2/vestarv/implementations/asic/castalia/analog/data/raw/px_grid_stb__sf34__stb_aol_db.csv" value(dB20(getData("loopGain" ?result "stb")) 1)))
    errset(mtxDump("/home/mseminario2/vestarv/implementations/asic/castalia/analog/data/raw/px_grid_stb__sf34__stb_pm.csv" (phaseMargin(getData("loopGain" ?result "stb")) + 180)))
  )
)

;; ---- corner 35 (ss35) / test px_grid_noise
when(isDir("/home/mseminario2/chips/castalia/ic/.simulation/castalia/tb_anatop_pixel/maestro/results/maestro/Interactive.20/35/PotTiaTB/psf")
  openResults("/home/mseminario2/chips/castalia/ic/.simulation/castalia/tb_anatop_pixel/maestro/results/maestro/Interactive.20/35/PotTiaTB/psf")
  when(member('noise results())
    selectResult('noise)
    mtxP = outfile("/home/mseminario2/vestarv/implementations/asic/castalia/analog/data/raw/px_grid_noise__ss35.meta" "w")
    fprintf(mtxP "sweep %%L\n" car(errset(sweepNames())))
    close(mtxP)
    errset(mtxDump("/home/mseminario2/vestarv/implementations/asic/castalia/analog/data/raw/px_grid_noise__ss35__grid_cdl.csv" VAR("cdl_we")))
    errset(mtxDump("/home/mseminario2/vestarv/implementations/asic/castalia/analog/data/raw/px_grid_noise__ss35__grid_rct.csv" VAR("rct_we")))
    errset(mtxDump("/home/mseminario2/vestarv/implementations/asic/castalia/analog/data/raw/px_grid_noise__ss35__grid_rf.csv" VAR("rf")))
    errset(mtxDump("/home/mseminario2/vestarv/implementations/asic/castalia/analog/data/raw/px_grid_noise__ss35__in_rma.csv" (rmsNoise(0.1 1000.0) / VAR("rf"))))
    errset(mtxDump("/home/mseminario2/vestarv/implementations/asic/castalia/analog/data/raw/px_grid_noise__ss35__vn_out.csv" rmsNoise(0.1 1000.0)))
  )
)

;; ---- corner 35 (ss35) / test px_grid_stb
when(isDir("/home/mseminario2/chips/castalia/ic/.simulation/castalia/tb_anatop_pixel/maestro/results/maestro/Interactive.20/35/PotTiaTB/psf")
  openResults("/home/mseminario2/chips/castalia/ic/.simulation/castalia/tb_anatop_pixel/maestro/results/maestro/Interactive.20/35/PotTiaTB/psf")
  when(member('stb results())
    selectResult('stb)
    mtxP = outfile("/home/mseminario2/vestarv/implementations/asic/castalia/analog/data/raw/px_grid_stb__ss35.meta" "w")
    fprintf(mtxP "sweep %%L\n" car(errset(sweepNames())))
    close(mtxP)
    errset(mtxDump("/home/mseminario2/vestarv/implementations/asic/castalia/analog/data/raw/px_grid_stb__ss35__grid_cdl.csv" VAR("cdl_we")))
    errset(mtxDump("/home/mseminario2/vestarv/implementations/asic/castalia/analog/data/raw/px_grid_stb__ss35__grid_rct.csv" VAR("rct_we")))
    errset(mtxDump("/home/mseminario2/vestarv/implementations/asic/castalia/analog/data/raw/px_grid_stb__ss35__grid_rf.csv" VAR("rf")))
    errset(mtxDump("/home/mseminario2/vestarv/implementations/asic/castalia/analog/data/raw/px_grid_stb__ss35__stb_aol_db.csv" value(dB20(getData("loopGain" ?result "stb")) 1)))
    errset(mtxDump("/home/mseminario2/vestarv/implementations/asic/castalia/analog/data/raw/px_grid_stb__ss35__stb_pm.csv" (phaseMargin(getData("loopGain" ?result "stb")) + 180)))
  )
)

;; ---- corner 36 (pt36) / test px_grid_noise
when(isDir("/home/mseminario2/chips/castalia/ic/.simulation/castalia/tb_anatop_pixel/maestro/results/maestro/Interactive.20/36/PotTiaTB/psf")
  openResults("/home/mseminario2/chips/castalia/ic/.simulation/castalia/tb_anatop_pixel/maestro/results/maestro/Interactive.20/36/PotTiaTB/psf")
  when(member('noise results())
    selectResult('noise)
    mtxP = outfile("/home/mseminario2/vestarv/implementations/asic/castalia/analog/data/raw/px_grid_noise__pt36.meta" "w")
    fprintf(mtxP "sweep %%L\n" car(errset(sweepNames())))
    close(mtxP)
    errset(mtxDump("/home/mseminario2/vestarv/implementations/asic/castalia/analog/data/raw/px_grid_noise__pt36__grid_cdl.csv" VAR("cdl_we")))
    errset(mtxDump("/home/mseminario2/vestarv/implementations/asic/castalia/analog/data/raw/px_grid_noise__pt36__grid_rct.csv" VAR("rct_we")))
    errset(mtxDump("/home/mseminario2/vestarv/implementations/asic/castalia/analog/data/raw/px_grid_noise__pt36__grid_rf.csv" VAR("rf")))
    errset(mtxDump("/home/mseminario2/vestarv/implementations/asic/castalia/analog/data/raw/px_grid_noise__pt36__in_rma.csv" (rmsNoise(0.1 1000.0) / VAR("rf"))))
    errset(mtxDump("/home/mseminario2/vestarv/implementations/asic/castalia/analog/data/raw/px_grid_noise__pt36__vn_out.csv" rmsNoise(0.1 1000.0)))
  )
)

;; ---- corner 36 (pt36) / test px_grid_stb
when(isDir("/home/mseminario2/chips/castalia/ic/.simulation/castalia/tb_anatop_pixel/maestro/results/maestro/Interactive.20/36/PotTiaTB/psf")
  openResults("/home/mseminario2/chips/castalia/ic/.simulation/castalia/tb_anatop_pixel/maestro/results/maestro/Interactive.20/36/PotTiaTB/psf")
  when(member('stb results())
    selectResult('stb)
    mtxP = outfile("/home/mseminario2/vestarv/implementations/asic/castalia/analog/data/raw/px_grid_stb__pt36.meta" "w")
    fprintf(mtxP "sweep %%L\n" car(errset(sweepNames())))
    close(mtxP)
    errset(mtxDump("/home/mseminario2/vestarv/implementations/asic/castalia/analog/data/raw/px_grid_stb__pt36__grid_cdl.csv" VAR("cdl_we")))
    errset(mtxDump("/home/mseminario2/vestarv/implementations/asic/castalia/analog/data/raw/px_grid_stb__pt36__grid_rct.csv" VAR("rct_we")))
    errset(mtxDump("/home/mseminario2/vestarv/implementations/asic/castalia/analog/data/raw/px_grid_stb__pt36__grid_rf.csv" VAR("rf")))
    errset(mtxDump("/home/mseminario2/vestarv/implementations/asic/castalia/analog/data/raw/px_grid_stb__pt36__stb_aol_db.csv" value(dB20(getData("loopGain" ?result "stb")) 1)))
    errset(mtxDump("/home/mseminario2/vestarv/implementations/asic/castalia/analog/data/raw/px_grid_stb__pt36__stb_pm.csv" (phaseMargin(getData("loopGain" ?result "stb")) + 180)))
  )
)

;; ---- corner 37 (ff37) / test px_grid_noise
when(isDir("/home/mseminario2/chips/castalia/ic/.simulation/castalia/tb_anatop_pixel/maestro/results/maestro/Interactive.20/37/PotTiaTB/psf")
  openResults("/home/mseminario2/chips/castalia/ic/.simulation/castalia/tb_anatop_pixel/maestro/results/maestro/Interactive.20/37/PotTiaTB/psf")
  when(member('noise results())
    selectResult('noise)
    mtxP = outfile("/home/mseminario2/vestarv/implementations/asic/castalia/analog/data/raw/px_grid_noise__ff37.meta" "w")
    fprintf(mtxP "sweep %%L\n" car(errset(sweepNames())))
    close(mtxP)
    errset(mtxDump("/home/mseminario2/vestarv/implementations/asic/castalia/analog/data/raw/px_grid_noise__ff37__grid_cdl.csv" VAR("cdl_we")))
    errset(mtxDump("/home/mseminario2/vestarv/implementations/asic/castalia/analog/data/raw/px_grid_noise__ff37__grid_rct.csv" VAR("rct_we")))
    errset(mtxDump("/home/mseminario2/vestarv/implementations/asic/castalia/analog/data/raw/px_grid_noise__ff37__grid_rf.csv" VAR("rf")))
    errset(mtxDump("/home/mseminario2/vestarv/implementations/asic/castalia/analog/data/raw/px_grid_noise__ff37__in_rma.csv" (rmsNoise(0.1 1000.0) / VAR("rf"))))
    errset(mtxDump("/home/mseminario2/vestarv/implementations/asic/castalia/analog/data/raw/px_grid_noise__ff37__vn_out.csv" rmsNoise(0.1 1000.0)))
  )
)

;; ---- corner 37 (ff37) / test px_grid_stb
when(isDir("/home/mseminario2/chips/castalia/ic/.simulation/castalia/tb_anatop_pixel/maestro/results/maestro/Interactive.20/37/PotTiaTB/psf")
  openResults("/home/mseminario2/chips/castalia/ic/.simulation/castalia/tb_anatop_pixel/maestro/results/maestro/Interactive.20/37/PotTiaTB/psf")
  when(member('stb results())
    selectResult('stb)
    mtxP = outfile("/home/mseminario2/vestarv/implementations/asic/castalia/analog/data/raw/px_grid_stb__ff37.meta" "w")
    fprintf(mtxP "sweep %%L\n" car(errset(sweepNames())))
    close(mtxP)
    errset(mtxDump("/home/mseminario2/vestarv/implementations/asic/castalia/analog/data/raw/px_grid_stb__ff37__grid_cdl.csv" VAR("cdl_we")))
    errset(mtxDump("/home/mseminario2/vestarv/implementations/asic/castalia/analog/data/raw/px_grid_stb__ff37__grid_rct.csv" VAR("rct_we")))
    errset(mtxDump("/home/mseminario2/vestarv/implementations/asic/castalia/analog/data/raw/px_grid_stb__ff37__grid_rf.csv" VAR("rf")))
    errset(mtxDump("/home/mseminario2/vestarv/implementations/asic/castalia/analog/data/raw/px_grid_stb__ff37__stb_aol_db.csv" value(dB20(getData("loopGain" ?result "stb")) 1)))
    errset(mtxDump("/home/mseminario2/vestarv/implementations/asic/castalia/analog/data/raw/px_grid_stb__ff37__stb_pm.csv" (phaseMargin(getData("loopGain" ?result "stb")) + 180)))
  )
)

;; ---- corner 38 (fs38) / test px_grid_noise
when(isDir("/home/mseminario2/chips/castalia/ic/.simulation/castalia/tb_anatop_pixel/maestro/results/maestro/Interactive.20/38/PotTiaTB/psf")
  openResults("/home/mseminario2/chips/castalia/ic/.simulation/castalia/tb_anatop_pixel/maestro/results/maestro/Interactive.20/38/PotTiaTB/psf")
  when(member('noise results())
    selectResult('noise)
    mtxP = outfile("/home/mseminario2/vestarv/implementations/asic/castalia/analog/data/raw/px_grid_noise__fs38.meta" "w")
    fprintf(mtxP "sweep %%L\n" car(errset(sweepNames())))
    close(mtxP)
    errset(mtxDump("/home/mseminario2/vestarv/implementations/asic/castalia/analog/data/raw/px_grid_noise__fs38__grid_cdl.csv" VAR("cdl_we")))
    errset(mtxDump("/home/mseminario2/vestarv/implementations/asic/castalia/analog/data/raw/px_grid_noise__fs38__grid_rct.csv" VAR("rct_we")))
    errset(mtxDump("/home/mseminario2/vestarv/implementations/asic/castalia/analog/data/raw/px_grid_noise__fs38__grid_rf.csv" VAR("rf")))
    errset(mtxDump("/home/mseminario2/vestarv/implementations/asic/castalia/analog/data/raw/px_grid_noise__fs38__in_rma.csv" (rmsNoise(0.1 1000.0) / VAR("rf"))))
    errset(mtxDump("/home/mseminario2/vestarv/implementations/asic/castalia/analog/data/raw/px_grid_noise__fs38__vn_out.csv" rmsNoise(0.1 1000.0)))
  )
)

;; ---- corner 38 (fs38) / test px_grid_stb
when(isDir("/home/mseminario2/chips/castalia/ic/.simulation/castalia/tb_anatop_pixel/maestro/results/maestro/Interactive.20/38/PotTiaTB/psf")
  openResults("/home/mseminario2/chips/castalia/ic/.simulation/castalia/tb_anatop_pixel/maestro/results/maestro/Interactive.20/38/PotTiaTB/psf")
  when(member('stb results())
    selectResult('stb)
    mtxP = outfile("/home/mseminario2/vestarv/implementations/asic/castalia/analog/data/raw/px_grid_stb__fs38.meta" "w")
    fprintf(mtxP "sweep %%L\n" car(errset(sweepNames())))
    close(mtxP)
    errset(mtxDump("/home/mseminario2/vestarv/implementations/asic/castalia/analog/data/raw/px_grid_stb__fs38__grid_cdl.csv" VAR("cdl_we")))
    errset(mtxDump("/home/mseminario2/vestarv/implementations/asic/castalia/analog/data/raw/px_grid_stb__fs38__grid_rct.csv" VAR("rct_we")))
    errset(mtxDump("/home/mseminario2/vestarv/implementations/asic/castalia/analog/data/raw/px_grid_stb__fs38__grid_rf.csv" VAR("rf")))
    errset(mtxDump("/home/mseminario2/vestarv/implementations/asic/castalia/analog/data/raw/px_grid_stb__fs38__stb_aol_db.csv" value(dB20(getData("loopGain" ?result "stb")) 1)))
    errset(mtxDump("/home/mseminario2/vestarv/implementations/asic/castalia/analog/data/raw/px_grid_stb__fs38__stb_pm.csv" (phaseMargin(getData("loopGain" ?result "stb")) + 180)))
  )
)

;; ---- corner 39 (sf39) / test px_grid_noise
when(isDir("/home/mseminario2/chips/castalia/ic/.simulation/castalia/tb_anatop_pixel/maestro/results/maestro/Interactive.20/39/PotTiaTB/psf")
  openResults("/home/mseminario2/chips/castalia/ic/.simulation/castalia/tb_anatop_pixel/maestro/results/maestro/Interactive.20/39/PotTiaTB/psf")
  when(member('noise results())
    selectResult('noise)
    mtxP = outfile("/home/mseminario2/vestarv/implementations/asic/castalia/analog/data/raw/px_grid_noise__sf39.meta" "w")
    fprintf(mtxP "sweep %%L\n" car(errset(sweepNames())))
    close(mtxP)
    errset(mtxDump("/home/mseminario2/vestarv/implementations/asic/castalia/analog/data/raw/px_grid_noise__sf39__grid_cdl.csv" VAR("cdl_we")))
    errset(mtxDump("/home/mseminario2/vestarv/implementations/asic/castalia/analog/data/raw/px_grid_noise__sf39__grid_rct.csv" VAR("rct_we")))
    errset(mtxDump("/home/mseminario2/vestarv/implementations/asic/castalia/analog/data/raw/px_grid_noise__sf39__grid_rf.csv" VAR("rf")))
    errset(mtxDump("/home/mseminario2/vestarv/implementations/asic/castalia/analog/data/raw/px_grid_noise__sf39__in_rma.csv" (rmsNoise(0.1 1000.0) / VAR("rf"))))
    errset(mtxDump("/home/mseminario2/vestarv/implementations/asic/castalia/analog/data/raw/px_grid_noise__sf39__vn_out.csv" rmsNoise(0.1 1000.0)))
  )
)

;; ---- corner 39 (sf39) / test px_grid_stb
when(isDir("/home/mseminario2/chips/castalia/ic/.simulation/castalia/tb_anatop_pixel/maestro/results/maestro/Interactive.20/39/PotTiaTB/psf")
  openResults("/home/mseminario2/chips/castalia/ic/.simulation/castalia/tb_anatop_pixel/maestro/results/maestro/Interactive.20/39/PotTiaTB/psf")
  when(member('stb results())
    selectResult('stb)
    mtxP = outfile("/home/mseminario2/vestarv/implementations/asic/castalia/analog/data/raw/px_grid_stb__sf39.meta" "w")
    fprintf(mtxP "sweep %%L\n" car(errset(sweepNames())))
    close(mtxP)
    errset(mtxDump("/home/mseminario2/vestarv/implementations/asic/castalia/analog/data/raw/px_grid_stb__sf39__grid_cdl.csv" VAR("cdl_we")))
    errset(mtxDump("/home/mseminario2/vestarv/implementations/asic/castalia/analog/data/raw/px_grid_stb__sf39__grid_rct.csv" VAR("rct_we")))
    errset(mtxDump("/home/mseminario2/vestarv/implementations/asic/castalia/analog/data/raw/px_grid_stb__sf39__grid_rf.csv" VAR("rf")))
    errset(mtxDump("/home/mseminario2/vestarv/implementations/asic/castalia/analog/data/raw/px_grid_stb__sf39__stb_aol_db.csv" value(dB20(getData("loopGain" ?result "stb")) 1)))
    errset(mtxDump("/home/mseminario2/vestarv/implementations/asic/castalia/analog/data/raw/px_grid_stb__sf39__stb_pm.csv" (phaseMargin(getData("loopGain" ?result "stb")) + 180)))
  )
)

;; ---- corner 40 (ss40) / test px_grid_noise
when(isDir("/home/mseminario2/chips/castalia/ic/.simulation/castalia/tb_anatop_pixel/maestro/results/maestro/Interactive.20/40/PotTiaTB/psf")
  openResults("/home/mseminario2/chips/castalia/ic/.simulation/castalia/tb_anatop_pixel/maestro/results/maestro/Interactive.20/40/PotTiaTB/psf")
  when(member('noise results())
    selectResult('noise)
    mtxP = outfile("/home/mseminario2/vestarv/implementations/asic/castalia/analog/data/raw/px_grid_noise__ss40.meta" "w")
    fprintf(mtxP "sweep %%L\n" car(errset(sweepNames())))
    close(mtxP)
    errset(mtxDump("/home/mseminario2/vestarv/implementations/asic/castalia/analog/data/raw/px_grid_noise__ss40__grid_cdl.csv" VAR("cdl_we")))
    errset(mtxDump("/home/mseminario2/vestarv/implementations/asic/castalia/analog/data/raw/px_grid_noise__ss40__grid_rct.csv" VAR("rct_we")))
    errset(mtxDump("/home/mseminario2/vestarv/implementations/asic/castalia/analog/data/raw/px_grid_noise__ss40__grid_rf.csv" VAR("rf")))
    errset(mtxDump("/home/mseminario2/vestarv/implementations/asic/castalia/analog/data/raw/px_grid_noise__ss40__in_rma.csv" (rmsNoise(0.1 1000.0) / VAR("rf"))))
    errset(mtxDump("/home/mseminario2/vestarv/implementations/asic/castalia/analog/data/raw/px_grid_noise__ss40__vn_out.csv" rmsNoise(0.1 1000.0)))
  )
)

;; ---- corner 40 (ss40) / test px_grid_stb
when(isDir("/home/mseminario2/chips/castalia/ic/.simulation/castalia/tb_anatop_pixel/maestro/results/maestro/Interactive.20/40/PotTiaTB/psf")
  openResults("/home/mseminario2/chips/castalia/ic/.simulation/castalia/tb_anatop_pixel/maestro/results/maestro/Interactive.20/40/PotTiaTB/psf")
  when(member('stb results())
    selectResult('stb)
    mtxP = outfile("/home/mseminario2/vestarv/implementations/asic/castalia/analog/data/raw/px_grid_stb__ss40.meta" "w")
    fprintf(mtxP "sweep %%L\n" car(errset(sweepNames())))
    close(mtxP)
    errset(mtxDump("/home/mseminario2/vestarv/implementations/asic/castalia/analog/data/raw/px_grid_stb__ss40__grid_cdl.csv" VAR("cdl_we")))
    errset(mtxDump("/home/mseminario2/vestarv/implementations/asic/castalia/analog/data/raw/px_grid_stb__ss40__grid_rct.csv" VAR("rct_we")))
    errset(mtxDump("/home/mseminario2/vestarv/implementations/asic/castalia/analog/data/raw/px_grid_stb__ss40__grid_rf.csv" VAR("rf")))
    errset(mtxDump("/home/mseminario2/vestarv/implementations/asic/castalia/analog/data/raw/px_grid_stb__ss40__stb_aol_db.csv" value(dB20(getData("loopGain" ?result "stb")) 1)))
    errset(mtxDump("/home/mseminario2/vestarv/implementations/asic/castalia/analog/data/raw/px_grid_stb__ss40__stb_pm.csv" (phaseMargin(getData("loopGain" ?result "stb")) + 180)))
  )
)

;; ---- corner 41 (pt41) / test px_grid_noise
when(isDir("/home/mseminario2/chips/castalia/ic/.simulation/castalia/tb_anatop_pixel/maestro/results/maestro/Interactive.20/41/PotTiaTB/psf")
  openResults("/home/mseminario2/chips/castalia/ic/.simulation/castalia/tb_anatop_pixel/maestro/results/maestro/Interactive.20/41/PotTiaTB/psf")
  when(member('noise results())
    selectResult('noise)
    mtxP = outfile("/home/mseminario2/vestarv/implementations/asic/castalia/analog/data/raw/px_grid_noise__pt41.meta" "w")
    fprintf(mtxP "sweep %%L\n" car(errset(sweepNames())))
    close(mtxP)
    errset(mtxDump("/home/mseminario2/vestarv/implementations/asic/castalia/analog/data/raw/px_grid_noise__pt41__grid_cdl.csv" VAR("cdl_we")))
    errset(mtxDump("/home/mseminario2/vestarv/implementations/asic/castalia/analog/data/raw/px_grid_noise__pt41__grid_rct.csv" VAR("rct_we")))
    errset(mtxDump("/home/mseminario2/vestarv/implementations/asic/castalia/analog/data/raw/px_grid_noise__pt41__grid_rf.csv" VAR("rf")))
    errset(mtxDump("/home/mseminario2/vestarv/implementations/asic/castalia/analog/data/raw/px_grid_noise__pt41__in_rma.csv" (rmsNoise(0.1 1000.0) / VAR("rf"))))
    errset(mtxDump("/home/mseminario2/vestarv/implementations/asic/castalia/analog/data/raw/px_grid_noise__pt41__vn_out.csv" rmsNoise(0.1 1000.0)))
  )
)

;; ---- corner 41 (pt41) / test px_grid_stb
when(isDir("/home/mseminario2/chips/castalia/ic/.simulation/castalia/tb_anatop_pixel/maestro/results/maestro/Interactive.20/41/PotTiaTB/psf")
  openResults("/home/mseminario2/chips/castalia/ic/.simulation/castalia/tb_anatop_pixel/maestro/results/maestro/Interactive.20/41/PotTiaTB/psf")
  when(member('stb results())
    selectResult('stb)
    mtxP = outfile("/home/mseminario2/vestarv/implementations/asic/castalia/analog/data/raw/px_grid_stb__pt41.meta" "w")
    fprintf(mtxP "sweep %%L\n" car(errset(sweepNames())))
    close(mtxP)
    errset(mtxDump("/home/mseminario2/vestarv/implementations/asic/castalia/analog/data/raw/px_grid_stb__pt41__grid_cdl.csv" VAR("cdl_we")))
    errset(mtxDump("/home/mseminario2/vestarv/implementations/asic/castalia/analog/data/raw/px_grid_stb__pt41__grid_rct.csv" VAR("rct_we")))
    errset(mtxDump("/home/mseminario2/vestarv/implementations/asic/castalia/analog/data/raw/px_grid_stb__pt41__grid_rf.csv" VAR("rf")))
    errset(mtxDump("/home/mseminario2/vestarv/implementations/asic/castalia/analog/data/raw/px_grid_stb__pt41__stb_aol_db.csv" value(dB20(getData("loopGain" ?result "stb")) 1)))
    errset(mtxDump("/home/mseminario2/vestarv/implementations/asic/castalia/analog/data/raw/px_grid_stb__pt41__stb_pm.csv" (phaseMargin(getData("loopGain" ?result "stb")) + 180)))
  )
)

;; ---- corner 42 (ff42) / test px_grid_noise
when(isDir("/home/mseminario2/chips/castalia/ic/.simulation/castalia/tb_anatop_pixel/maestro/results/maestro/Interactive.20/42/PotTiaTB/psf")
  openResults("/home/mseminario2/chips/castalia/ic/.simulation/castalia/tb_anatop_pixel/maestro/results/maestro/Interactive.20/42/PotTiaTB/psf")
  when(member('noise results())
    selectResult('noise)
    mtxP = outfile("/home/mseminario2/vestarv/implementations/asic/castalia/analog/data/raw/px_grid_noise__ff42.meta" "w")
    fprintf(mtxP "sweep %%L\n" car(errset(sweepNames())))
    close(mtxP)
    errset(mtxDump("/home/mseminario2/vestarv/implementations/asic/castalia/analog/data/raw/px_grid_noise__ff42__grid_cdl.csv" VAR("cdl_we")))
    errset(mtxDump("/home/mseminario2/vestarv/implementations/asic/castalia/analog/data/raw/px_grid_noise__ff42__grid_rct.csv" VAR("rct_we")))
    errset(mtxDump("/home/mseminario2/vestarv/implementations/asic/castalia/analog/data/raw/px_grid_noise__ff42__grid_rf.csv" VAR("rf")))
    errset(mtxDump("/home/mseminario2/vestarv/implementations/asic/castalia/analog/data/raw/px_grid_noise__ff42__in_rma.csv" (rmsNoise(0.1 1000.0) / VAR("rf"))))
    errset(mtxDump("/home/mseminario2/vestarv/implementations/asic/castalia/analog/data/raw/px_grid_noise__ff42__vn_out.csv" rmsNoise(0.1 1000.0)))
  )
)

;; ---- corner 42 (ff42) / test px_grid_stb
when(isDir("/home/mseminario2/chips/castalia/ic/.simulation/castalia/tb_anatop_pixel/maestro/results/maestro/Interactive.20/42/PotTiaTB/psf")
  openResults("/home/mseminario2/chips/castalia/ic/.simulation/castalia/tb_anatop_pixel/maestro/results/maestro/Interactive.20/42/PotTiaTB/psf")
  when(member('stb results())
    selectResult('stb)
    mtxP = outfile("/home/mseminario2/vestarv/implementations/asic/castalia/analog/data/raw/px_grid_stb__ff42.meta" "w")
    fprintf(mtxP "sweep %%L\n" car(errset(sweepNames())))
    close(mtxP)
    errset(mtxDump("/home/mseminario2/vestarv/implementations/asic/castalia/analog/data/raw/px_grid_stb__ff42__grid_cdl.csv" VAR("cdl_we")))
    errset(mtxDump("/home/mseminario2/vestarv/implementations/asic/castalia/analog/data/raw/px_grid_stb__ff42__grid_rct.csv" VAR("rct_we")))
    errset(mtxDump("/home/mseminario2/vestarv/implementations/asic/castalia/analog/data/raw/px_grid_stb__ff42__grid_rf.csv" VAR("rf")))
    errset(mtxDump("/home/mseminario2/vestarv/implementations/asic/castalia/analog/data/raw/px_grid_stb__ff42__stb_aol_db.csv" value(dB20(getData("loopGain" ?result "stb")) 1)))
    errset(mtxDump("/home/mseminario2/vestarv/implementations/asic/castalia/analog/data/raw/px_grid_stb__ff42__stb_pm.csv" (phaseMargin(getData("loopGain" ?result "stb")) + 180)))
  )
)

;; ---- corner 43 (fs43) / test px_grid_noise
when(isDir("/home/mseminario2/chips/castalia/ic/.simulation/castalia/tb_anatop_pixel/maestro/results/maestro/Interactive.20/43/PotTiaTB/psf")
  openResults("/home/mseminario2/chips/castalia/ic/.simulation/castalia/tb_anatop_pixel/maestro/results/maestro/Interactive.20/43/PotTiaTB/psf")
  when(member('noise results())
    selectResult('noise)
    mtxP = outfile("/home/mseminario2/vestarv/implementations/asic/castalia/analog/data/raw/px_grid_noise__fs43.meta" "w")
    fprintf(mtxP "sweep %%L\n" car(errset(sweepNames())))
    close(mtxP)
    errset(mtxDump("/home/mseminario2/vestarv/implementations/asic/castalia/analog/data/raw/px_grid_noise__fs43__grid_cdl.csv" VAR("cdl_we")))
    errset(mtxDump("/home/mseminario2/vestarv/implementations/asic/castalia/analog/data/raw/px_grid_noise__fs43__grid_rct.csv" VAR("rct_we")))
    errset(mtxDump("/home/mseminario2/vestarv/implementations/asic/castalia/analog/data/raw/px_grid_noise__fs43__grid_rf.csv" VAR("rf")))
    errset(mtxDump("/home/mseminario2/vestarv/implementations/asic/castalia/analog/data/raw/px_grid_noise__fs43__in_rma.csv" (rmsNoise(0.1 1000.0) / VAR("rf"))))
    errset(mtxDump("/home/mseminario2/vestarv/implementations/asic/castalia/analog/data/raw/px_grid_noise__fs43__vn_out.csv" rmsNoise(0.1 1000.0)))
  )
)

;; ---- corner 43 (fs43) / test px_grid_stb
when(isDir("/home/mseminario2/chips/castalia/ic/.simulation/castalia/tb_anatop_pixel/maestro/results/maestro/Interactive.20/43/PotTiaTB/psf")
  openResults("/home/mseminario2/chips/castalia/ic/.simulation/castalia/tb_anatop_pixel/maestro/results/maestro/Interactive.20/43/PotTiaTB/psf")
  when(member('stb results())
    selectResult('stb)
    mtxP = outfile("/home/mseminario2/vestarv/implementations/asic/castalia/analog/data/raw/px_grid_stb__fs43.meta" "w")
    fprintf(mtxP "sweep %%L\n" car(errset(sweepNames())))
    close(mtxP)
    errset(mtxDump("/home/mseminario2/vestarv/implementations/asic/castalia/analog/data/raw/px_grid_stb__fs43__grid_cdl.csv" VAR("cdl_we")))
    errset(mtxDump("/home/mseminario2/vestarv/implementations/asic/castalia/analog/data/raw/px_grid_stb__fs43__grid_rct.csv" VAR("rct_we")))
    errset(mtxDump("/home/mseminario2/vestarv/implementations/asic/castalia/analog/data/raw/px_grid_stb__fs43__grid_rf.csv" VAR("rf")))
    errset(mtxDump("/home/mseminario2/vestarv/implementations/asic/castalia/analog/data/raw/px_grid_stb__fs43__stb_aol_db.csv" value(dB20(getData("loopGain" ?result "stb")) 1)))
    errset(mtxDump("/home/mseminario2/vestarv/implementations/asic/castalia/analog/data/raw/px_grid_stb__fs43__stb_pm.csv" (phaseMargin(getData("loopGain" ?result "stb")) + 180)))
  )
)

;; ---- corner 44 (sf44) / test px_grid_noise
when(isDir("/home/mseminario2/chips/castalia/ic/.simulation/castalia/tb_anatop_pixel/maestro/results/maestro/Interactive.20/44/PotTiaTB/psf")
  openResults("/home/mseminario2/chips/castalia/ic/.simulation/castalia/tb_anatop_pixel/maestro/results/maestro/Interactive.20/44/PotTiaTB/psf")
  when(member('noise results())
    selectResult('noise)
    mtxP = outfile("/home/mseminario2/vestarv/implementations/asic/castalia/analog/data/raw/px_grid_noise__sf44.meta" "w")
    fprintf(mtxP "sweep %%L\n" car(errset(sweepNames())))
    close(mtxP)
    errset(mtxDump("/home/mseminario2/vestarv/implementations/asic/castalia/analog/data/raw/px_grid_noise__sf44__grid_cdl.csv" VAR("cdl_we")))
    errset(mtxDump("/home/mseminario2/vestarv/implementations/asic/castalia/analog/data/raw/px_grid_noise__sf44__grid_rct.csv" VAR("rct_we")))
    errset(mtxDump("/home/mseminario2/vestarv/implementations/asic/castalia/analog/data/raw/px_grid_noise__sf44__grid_rf.csv" VAR("rf")))
    errset(mtxDump("/home/mseminario2/vestarv/implementations/asic/castalia/analog/data/raw/px_grid_noise__sf44__in_rma.csv" (rmsNoise(0.1 1000.0) / VAR("rf"))))
    errset(mtxDump("/home/mseminario2/vestarv/implementations/asic/castalia/analog/data/raw/px_grid_noise__sf44__vn_out.csv" rmsNoise(0.1 1000.0)))
  )
)

;; ---- corner 44 (sf44) / test px_grid_stb
when(isDir("/home/mseminario2/chips/castalia/ic/.simulation/castalia/tb_anatop_pixel/maestro/results/maestro/Interactive.20/44/PotTiaTB/psf")
  openResults("/home/mseminario2/chips/castalia/ic/.simulation/castalia/tb_anatop_pixel/maestro/results/maestro/Interactive.20/44/PotTiaTB/psf")
  when(member('stb results())
    selectResult('stb)
    mtxP = outfile("/home/mseminario2/vestarv/implementations/asic/castalia/analog/data/raw/px_grid_stb__sf44.meta" "w")
    fprintf(mtxP "sweep %%L\n" car(errset(sweepNames())))
    close(mtxP)
    errset(mtxDump("/home/mseminario2/vestarv/implementations/asic/castalia/analog/data/raw/px_grid_stb__sf44__grid_cdl.csv" VAR("cdl_we")))
    errset(mtxDump("/home/mseminario2/vestarv/implementations/asic/castalia/analog/data/raw/px_grid_stb__sf44__grid_rct.csv" VAR("rct_we")))
    errset(mtxDump("/home/mseminario2/vestarv/implementations/asic/castalia/analog/data/raw/px_grid_stb__sf44__grid_rf.csv" VAR("rf")))
    errset(mtxDump("/home/mseminario2/vestarv/implementations/asic/castalia/analog/data/raw/px_grid_stb__sf44__stb_aol_db.csv" value(dB20(getData("loopGain" ?result "stb")) 1)))
    errset(mtxDump("/home/mseminario2/vestarv/implementations/asic/castalia/analog/data/raw/px_grid_stb__sf44__stb_pm.csv" (phaseMargin(getData("loopGain" ?result "stb")) + 180)))
  )
)

;; ---- corner 45 (ss45) / test px_grid_noise
when(isDir("/home/mseminario2/chips/castalia/ic/.simulation/castalia/tb_anatop_pixel/maestro/results/maestro/Interactive.20/45/PotTiaTB/psf")
  openResults("/home/mseminario2/chips/castalia/ic/.simulation/castalia/tb_anatop_pixel/maestro/results/maestro/Interactive.20/45/PotTiaTB/psf")
  when(member('noise results())
    selectResult('noise)
    mtxP = outfile("/home/mseminario2/vestarv/implementations/asic/castalia/analog/data/raw/px_grid_noise__ss45.meta" "w")
    fprintf(mtxP "sweep %%L\n" car(errset(sweepNames())))
    close(mtxP)
    errset(mtxDump("/home/mseminario2/vestarv/implementations/asic/castalia/analog/data/raw/px_grid_noise__ss45__grid_cdl.csv" VAR("cdl_we")))
    errset(mtxDump("/home/mseminario2/vestarv/implementations/asic/castalia/analog/data/raw/px_grid_noise__ss45__grid_rct.csv" VAR("rct_we")))
    errset(mtxDump("/home/mseminario2/vestarv/implementations/asic/castalia/analog/data/raw/px_grid_noise__ss45__grid_rf.csv" VAR("rf")))
    errset(mtxDump("/home/mseminario2/vestarv/implementations/asic/castalia/analog/data/raw/px_grid_noise__ss45__in_rma.csv" (rmsNoise(0.1 1000.0) / VAR("rf"))))
    errset(mtxDump("/home/mseminario2/vestarv/implementations/asic/castalia/analog/data/raw/px_grid_noise__ss45__vn_out.csv" rmsNoise(0.1 1000.0)))
  )
)

;; ---- corner 45 (ss45) / test px_grid_stb
when(isDir("/home/mseminario2/chips/castalia/ic/.simulation/castalia/tb_anatop_pixel/maestro/results/maestro/Interactive.20/45/PotTiaTB/psf")
  openResults("/home/mseminario2/chips/castalia/ic/.simulation/castalia/tb_anatop_pixel/maestro/results/maestro/Interactive.20/45/PotTiaTB/psf")
  when(member('stb results())
    selectResult('stb)
    mtxP = outfile("/home/mseminario2/vestarv/implementations/asic/castalia/analog/data/raw/px_grid_stb__ss45.meta" "w")
    fprintf(mtxP "sweep %%L\n" car(errset(sweepNames())))
    close(mtxP)
    errset(mtxDump("/home/mseminario2/vestarv/implementations/asic/castalia/analog/data/raw/px_grid_stb__ss45__grid_cdl.csv" VAR("cdl_we")))
    errset(mtxDump("/home/mseminario2/vestarv/implementations/asic/castalia/analog/data/raw/px_grid_stb__ss45__grid_rct.csv" VAR("rct_we")))
    errset(mtxDump("/home/mseminario2/vestarv/implementations/asic/castalia/analog/data/raw/px_grid_stb__ss45__grid_rf.csv" VAR("rf")))
    errset(mtxDump("/home/mseminario2/vestarv/implementations/asic/castalia/analog/data/raw/px_grid_stb__ss45__stb_aol_db.csv" value(dB20(getData("loopGain" ?result "stb")) 1)))
    errset(mtxDump("/home/mseminario2/vestarv/implementations/asic/castalia/analog/data/raw/px_grid_stb__ss45__stb_pm.csv" (phaseMargin(getData("loopGain" ?result "stb")) + 180)))
  )
)

;; ---- corner 46 (pt46) / test px_grid_noise
when(isDir("/home/mseminario2/chips/castalia/ic/.simulation/castalia/tb_anatop_pixel/maestro/results/maestro/Interactive.20/46/PotTiaTB/psf")
  openResults("/home/mseminario2/chips/castalia/ic/.simulation/castalia/tb_anatop_pixel/maestro/results/maestro/Interactive.20/46/PotTiaTB/psf")
  when(member('noise results())
    selectResult('noise)
    mtxP = outfile("/home/mseminario2/vestarv/implementations/asic/castalia/analog/data/raw/px_grid_noise__pt46.meta" "w")
    fprintf(mtxP "sweep %%L\n" car(errset(sweepNames())))
    close(mtxP)
    errset(mtxDump("/home/mseminario2/vestarv/implementations/asic/castalia/analog/data/raw/px_grid_noise__pt46__grid_cdl.csv" VAR("cdl_we")))
    errset(mtxDump("/home/mseminario2/vestarv/implementations/asic/castalia/analog/data/raw/px_grid_noise__pt46__grid_rct.csv" VAR("rct_we")))
    errset(mtxDump("/home/mseminario2/vestarv/implementations/asic/castalia/analog/data/raw/px_grid_noise__pt46__grid_rf.csv" VAR("rf")))
    errset(mtxDump("/home/mseminario2/vestarv/implementations/asic/castalia/analog/data/raw/px_grid_noise__pt46__in_rma.csv" (rmsNoise(0.1 1000.0) / VAR("rf"))))
    errset(mtxDump("/home/mseminario2/vestarv/implementations/asic/castalia/analog/data/raw/px_grid_noise__pt46__vn_out.csv" rmsNoise(0.1 1000.0)))
  )
)

;; ---- corner 46 (pt46) / test px_grid_stb
when(isDir("/home/mseminario2/chips/castalia/ic/.simulation/castalia/tb_anatop_pixel/maestro/results/maestro/Interactive.20/46/PotTiaTB/psf")
  openResults("/home/mseminario2/chips/castalia/ic/.simulation/castalia/tb_anatop_pixel/maestro/results/maestro/Interactive.20/46/PotTiaTB/psf")
  when(member('stb results())
    selectResult('stb)
    mtxP = outfile("/home/mseminario2/vestarv/implementations/asic/castalia/analog/data/raw/px_grid_stb__pt46.meta" "w")
    fprintf(mtxP "sweep %%L\n" car(errset(sweepNames())))
    close(mtxP)
    errset(mtxDump("/home/mseminario2/vestarv/implementations/asic/castalia/analog/data/raw/px_grid_stb__pt46__grid_cdl.csv" VAR("cdl_we")))
    errset(mtxDump("/home/mseminario2/vestarv/implementations/asic/castalia/analog/data/raw/px_grid_stb__pt46__grid_rct.csv" VAR("rct_we")))
    errset(mtxDump("/home/mseminario2/vestarv/implementations/asic/castalia/analog/data/raw/px_grid_stb__pt46__grid_rf.csv" VAR("rf")))
    errset(mtxDump("/home/mseminario2/vestarv/implementations/asic/castalia/analog/data/raw/px_grid_stb__pt46__stb_aol_db.csv" value(dB20(getData("loopGain" ?result "stb")) 1)))
    errset(mtxDump("/home/mseminario2/vestarv/implementations/asic/castalia/analog/data/raw/px_grid_stb__pt46__stb_pm.csv" (phaseMargin(getData("loopGain" ?result "stb")) + 180)))
  )
)

;; ---- corner 47 (ff47) / test px_grid_noise
when(isDir("/home/mseminario2/chips/castalia/ic/.simulation/castalia/tb_anatop_pixel/maestro/results/maestro/Interactive.20/47/PotTiaTB/psf")
  openResults("/home/mseminario2/chips/castalia/ic/.simulation/castalia/tb_anatop_pixel/maestro/results/maestro/Interactive.20/47/PotTiaTB/psf")
  when(member('noise results())
    selectResult('noise)
    mtxP = outfile("/home/mseminario2/vestarv/implementations/asic/castalia/analog/data/raw/px_grid_noise__ff47.meta" "w")
    fprintf(mtxP "sweep %%L\n" car(errset(sweepNames())))
    close(mtxP)
    errset(mtxDump("/home/mseminario2/vestarv/implementations/asic/castalia/analog/data/raw/px_grid_noise__ff47__grid_cdl.csv" VAR("cdl_we")))
    errset(mtxDump("/home/mseminario2/vestarv/implementations/asic/castalia/analog/data/raw/px_grid_noise__ff47__grid_rct.csv" VAR("rct_we")))
    errset(mtxDump("/home/mseminario2/vestarv/implementations/asic/castalia/analog/data/raw/px_grid_noise__ff47__grid_rf.csv" VAR("rf")))
    errset(mtxDump("/home/mseminario2/vestarv/implementations/asic/castalia/analog/data/raw/px_grid_noise__ff47__in_rma.csv" (rmsNoise(0.1 1000.0) / VAR("rf"))))
    errset(mtxDump("/home/mseminario2/vestarv/implementations/asic/castalia/analog/data/raw/px_grid_noise__ff47__vn_out.csv" rmsNoise(0.1 1000.0)))
  )
)

;; ---- corner 47 (ff47) / test px_grid_stb
when(isDir("/home/mseminario2/chips/castalia/ic/.simulation/castalia/tb_anatop_pixel/maestro/results/maestro/Interactive.20/47/PotTiaTB/psf")
  openResults("/home/mseminario2/chips/castalia/ic/.simulation/castalia/tb_anatop_pixel/maestro/results/maestro/Interactive.20/47/PotTiaTB/psf")
  when(member('stb results())
    selectResult('stb)
    mtxP = outfile("/home/mseminario2/vestarv/implementations/asic/castalia/analog/data/raw/px_grid_stb__ff47.meta" "w")
    fprintf(mtxP "sweep %%L\n" car(errset(sweepNames())))
    close(mtxP)
    errset(mtxDump("/home/mseminario2/vestarv/implementations/asic/castalia/analog/data/raw/px_grid_stb__ff47__grid_cdl.csv" VAR("cdl_we")))
    errset(mtxDump("/home/mseminario2/vestarv/implementations/asic/castalia/analog/data/raw/px_grid_stb__ff47__grid_rct.csv" VAR("rct_we")))
    errset(mtxDump("/home/mseminario2/vestarv/implementations/asic/castalia/analog/data/raw/px_grid_stb__ff47__grid_rf.csv" VAR("rf")))
    errset(mtxDump("/home/mseminario2/vestarv/implementations/asic/castalia/analog/data/raw/px_grid_stb__ff47__stb_aol_db.csv" value(dB20(getData("loopGain" ?result "stb")) 1)))
    errset(mtxDump("/home/mseminario2/vestarv/implementations/asic/castalia/analog/data/raw/px_grid_stb__ff47__stb_pm.csv" (phaseMargin(getData("loopGain" ?result "stb")) + 180)))
  )
)

;; ---- corner 48 (fs48) / test px_grid_noise
when(isDir("/home/mseminario2/chips/castalia/ic/.simulation/castalia/tb_anatop_pixel/maestro/results/maestro/Interactive.20/48/PotTiaTB/psf")
  openResults("/home/mseminario2/chips/castalia/ic/.simulation/castalia/tb_anatop_pixel/maestro/results/maestro/Interactive.20/48/PotTiaTB/psf")
  when(member('noise results())
    selectResult('noise)
    mtxP = outfile("/home/mseminario2/vestarv/implementations/asic/castalia/analog/data/raw/px_grid_noise__fs48.meta" "w")
    fprintf(mtxP "sweep %%L\n" car(errset(sweepNames())))
    close(mtxP)
    errset(mtxDump("/home/mseminario2/vestarv/implementations/asic/castalia/analog/data/raw/px_grid_noise__fs48__grid_cdl.csv" VAR("cdl_we")))
    errset(mtxDump("/home/mseminario2/vestarv/implementations/asic/castalia/analog/data/raw/px_grid_noise__fs48__grid_rct.csv" VAR("rct_we")))
    errset(mtxDump("/home/mseminario2/vestarv/implementations/asic/castalia/analog/data/raw/px_grid_noise__fs48__grid_rf.csv" VAR("rf")))
    errset(mtxDump("/home/mseminario2/vestarv/implementations/asic/castalia/analog/data/raw/px_grid_noise__fs48__in_rma.csv" (rmsNoise(0.1 1000.0) / VAR("rf"))))
    errset(mtxDump("/home/mseminario2/vestarv/implementations/asic/castalia/analog/data/raw/px_grid_noise__fs48__vn_out.csv" rmsNoise(0.1 1000.0)))
  )
)

;; ---- corner 48 (fs48) / test px_grid_stb
when(isDir("/home/mseminario2/chips/castalia/ic/.simulation/castalia/tb_anatop_pixel/maestro/results/maestro/Interactive.20/48/PotTiaTB/psf")
  openResults("/home/mseminario2/chips/castalia/ic/.simulation/castalia/tb_anatop_pixel/maestro/results/maestro/Interactive.20/48/PotTiaTB/psf")
  when(member('stb results())
    selectResult('stb)
    mtxP = outfile("/home/mseminario2/vestarv/implementations/asic/castalia/analog/data/raw/px_grid_stb__fs48.meta" "w")
    fprintf(mtxP "sweep %%L\n" car(errset(sweepNames())))
    close(mtxP)
    errset(mtxDump("/home/mseminario2/vestarv/implementations/asic/castalia/analog/data/raw/px_grid_stb__fs48__grid_cdl.csv" VAR("cdl_we")))
    errset(mtxDump("/home/mseminario2/vestarv/implementations/asic/castalia/analog/data/raw/px_grid_stb__fs48__grid_rct.csv" VAR("rct_we")))
    errset(mtxDump("/home/mseminario2/vestarv/implementations/asic/castalia/analog/data/raw/px_grid_stb__fs48__grid_rf.csv" VAR("rf")))
    errset(mtxDump("/home/mseminario2/vestarv/implementations/asic/castalia/analog/data/raw/px_grid_stb__fs48__stb_aol_db.csv" value(dB20(getData("loopGain" ?result "stb")) 1)))
    errset(mtxDump("/home/mseminario2/vestarv/implementations/asic/castalia/analog/data/raw/px_grid_stb__fs48__stb_pm.csv" (phaseMargin(getData("loopGain" ?result "stb")) + 180)))
  )
)

;; ---- corner 49 (sf49) / test px_grid_noise
when(isDir("/home/mseminario2/chips/castalia/ic/.simulation/castalia/tb_anatop_pixel/maestro/results/maestro/Interactive.20/49/PotTiaTB/psf")
  openResults("/home/mseminario2/chips/castalia/ic/.simulation/castalia/tb_anatop_pixel/maestro/results/maestro/Interactive.20/49/PotTiaTB/psf")
  when(member('noise results())
    selectResult('noise)
    mtxP = outfile("/home/mseminario2/vestarv/implementations/asic/castalia/analog/data/raw/px_grid_noise__sf49.meta" "w")
    fprintf(mtxP "sweep %%L\n" car(errset(sweepNames())))
    close(mtxP)
    errset(mtxDump("/home/mseminario2/vestarv/implementations/asic/castalia/analog/data/raw/px_grid_noise__sf49__grid_cdl.csv" VAR("cdl_we")))
    errset(mtxDump("/home/mseminario2/vestarv/implementations/asic/castalia/analog/data/raw/px_grid_noise__sf49__grid_rct.csv" VAR("rct_we")))
    errset(mtxDump("/home/mseminario2/vestarv/implementations/asic/castalia/analog/data/raw/px_grid_noise__sf49__grid_rf.csv" VAR("rf")))
    errset(mtxDump("/home/mseminario2/vestarv/implementations/asic/castalia/analog/data/raw/px_grid_noise__sf49__in_rma.csv" (rmsNoise(0.1 1000.0) / VAR("rf"))))
    errset(mtxDump("/home/mseminario2/vestarv/implementations/asic/castalia/analog/data/raw/px_grid_noise__sf49__vn_out.csv" rmsNoise(0.1 1000.0)))
  )
)

;; ---- corner 49 (sf49) / test px_grid_stb
when(isDir("/home/mseminario2/chips/castalia/ic/.simulation/castalia/tb_anatop_pixel/maestro/results/maestro/Interactive.20/49/PotTiaTB/psf")
  openResults("/home/mseminario2/chips/castalia/ic/.simulation/castalia/tb_anatop_pixel/maestro/results/maestro/Interactive.20/49/PotTiaTB/psf")
  when(member('stb results())
    selectResult('stb)
    mtxP = outfile("/home/mseminario2/vestarv/implementations/asic/castalia/analog/data/raw/px_grid_stb__sf49.meta" "w")
    fprintf(mtxP "sweep %%L\n" car(errset(sweepNames())))
    close(mtxP)
    errset(mtxDump("/home/mseminario2/vestarv/implementations/asic/castalia/analog/data/raw/px_grid_stb__sf49__grid_cdl.csv" VAR("cdl_we")))
    errset(mtxDump("/home/mseminario2/vestarv/implementations/asic/castalia/analog/data/raw/px_grid_stb__sf49__grid_rct.csv" VAR("rct_we")))
    errset(mtxDump("/home/mseminario2/vestarv/implementations/asic/castalia/analog/data/raw/px_grid_stb__sf49__grid_rf.csv" VAR("rf")))
    errset(mtxDump("/home/mseminario2/vestarv/implementations/asic/castalia/analog/data/raw/px_grid_stb__sf49__stb_aol_db.csv" value(dB20(getData("loopGain" ?result "stb")) 1)))
    errset(mtxDump("/home/mseminario2/vestarv/implementations/asic/castalia/analog/data/raw/px_grid_stb__sf49__stb_pm.csv" (phaseMargin(getData("loopGain" ?result "stb")) + 180)))
  )
)

;; ---- corner 50 (ss50) / test px_grid_noise
when(isDir("/home/mseminario2/chips/castalia/ic/.simulation/castalia/tb_anatop_pixel/maestro/results/maestro/Interactive.20/50/PotTiaTB/psf")
  openResults("/home/mseminario2/chips/castalia/ic/.simulation/castalia/tb_anatop_pixel/maestro/results/maestro/Interactive.20/50/PotTiaTB/psf")
  when(member('noise results())
    selectResult('noise)
    mtxP = outfile("/home/mseminario2/vestarv/implementations/asic/castalia/analog/data/raw/px_grid_noise__ss50.meta" "w")
    fprintf(mtxP "sweep %%L\n" car(errset(sweepNames())))
    close(mtxP)
    errset(mtxDump("/home/mseminario2/vestarv/implementations/asic/castalia/analog/data/raw/px_grid_noise__ss50__grid_cdl.csv" VAR("cdl_we")))
    errset(mtxDump("/home/mseminario2/vestarv/implementations/asic/castalia/analog/data/raw/px_grid_noise__ss50__grid_rct.csv" VAR("rct_we")))
    errset(mtxDump("/home/mseminario2/vestarv/implementations/asic/castalia/analog/data/raw/px_grid_noise__ss50__grid_rf.csv" VAR("rf")))
    errset(mtxDump("/home/mseminario2/vestarv/implementations/asic/castalia/analog/data/raw/px_grid_noise__ss50__in_rma.csv" (rmsNoise(0.1 1000.0) / VAR("rf"))))
    errset(mtxDump("/home/mseminario2/vestarv/implementations/asic/castalia/analog/data/raw/px_grid_noise__ss50__vn_out.csv" rmsNoise(0.1 1000.0)))
  )
)

;; ---- corner 50 (ss50) / test px_grid_stb
when(isDir("/home/mseminario2/chips/castalia/ic/.simulation/castalia/tb_anatop_pixel/maestro/results/maestro/Interactive.20/50/PotTiaTB/psf")
  openResults("/home/mseminario2/chips/castalia/ic/.simulation/castalia/tb_anatop_pixel/maestro/results/maestro/Interactive.20/50/PotTiaTB/psf")
  when(member('stb results())
    selectResult('stb)
    mtxP = outfile("/home/mseminario2/vestarv/implementations/asic/castalia/analog/data/raw/px_grid_stb__ss50.meta" "w")
    fprintf(mtxP "sweep %%L\n" car(errset(sweepNames())))
    close(mtxP)
    errset(mtxDump("/home/mseminario2/vestarv/implementations/asic/castalia/analog/data/raw/px_grid_stb__ss50__grid_cdl.csv" VAR("cdl_we")))
    errset(mtxDump("/home/mseminario2/vestarv/implementations/asic/castalia/analog/data/raw/px_grid_stb__ss50__grid_rct.csv" VAR("rct_we")))
    errset(mtxDump("/home/mseminario2/vestarv/implementations/asic/castalia/analog/data/raw/px_grid_stb__ss50__grid_rf.csv" VAR("rf")))
    errset(mtxDump("/home/mseminario2/vestarv/implementations/asic/castalia/analog/data/raw/px_grid_stb__ss50__stb_aol_db.csv" value(dB20(getData("loopGain" ?result "stb")) 1)))
    errset(mtxDump("/home/mseminario2/vestarv/implementations/asic/castalia/analog/data/raw/px_grid_stb__ss50__stb_pm.csv" (phaseMargin(getData("loopGain" ?result "stb")) + 180)))
  )
)

;; ---- corner 51 (pt51) / test px_grid_noise
when(isDir("/home/mseminario2/chips/castalia/ic/.simulation/castalia/tb_anatop_pixel/maestro/results/maestro/Interactive.20/51/PotTiaTB/psf")
  openResults("/home/mseminario2/chips/castalia/ic/.simulation/castalia/tb_anatop_pixel/maestro/results/maestro/Interactive.20/51/PotTiaTB/psf")
  when(member('noise results())
    selectResult('noise)
    mtxP = outfile("/home/mseminario2/vestarv/implementations/asic/castalia/analog/data/raw/px_grid_noise__pt51.meta" "w")
    fprintf(mtxP "sweep %%L\n" car(errset(sweepNames())))
    close(mtxP)
    errset(mtxDump("/home/mseminario2/vestarv/implementations/asic/castalia/analog/data/raw/px_grid_noise__pt51__grid_cdl.csv" VAR("cdl_we")))
    errset(mtxDump("/home/mseminario2/vestarv/implementations/asic/castalia/analog/data/raw/px_grid_noise__pt51__grid_rct.csv" VAR("rct_we")))
    errset(mtxDump("/home/mseminario2/vestarv/implementations/asic/castalia/analog/data/raw/px_grid_noise__pt51__grid_rf.csv" VAR("rf")))
    errset(mtxDump("/home/mseminario2/vestarv/implementations/asic/castalia/analog/data/raw/px_grid_noise__pt51__in_rma.csv" (rmsNoise(0.1 1000.0) / VAR("rf"))))
    errset(mtxDump("/home/mseminario2/vestarv/implementations/asic/castalia/analog/data/raw/px_grid_noise__pt51__vn_out.csv" rmsNoise(0.1 1000.0)))
  )
)

;; ---- corner 51 (pt51) / test px_grid_stb
when(isDir("/home/mseminario2/chips/castalia/ic/.simulation/castalia/tb_anatop_pixel/maestro/results/maestro/Interactive.20/51/PotTiaTB/psf")
  openResults("/home/mseminario2/chips/castalia/ic/.simulation/castalia/tb_anatop_pixel/maestro/results/maestro/Interactive.20/51/PotTiaTB/psf")
  when(member('stb results())
    selectResult('stb)
    mtxP = outfile("/home/mseminario2/vestarv/implementations/asic/castalia/analog/data/raw/px_grid_stb__pt51.meta" "w")
    fprintf(mtxP "sweep %%L\n" car(errset(sweepNames())))
    close(mtxP)
    errset(mtxDump("/home/mseminario2/vestarv/implementations/asic/castalia/analog/data/raw/px_grid_stb__pt51__grid_cdl.csv" VAR("cdl_we")))
    errset(mtxDump("/home/mseminario2/vestarv/implementations/asic/castalia/analog/data/raw/px_grid_stb__pt51__grid_rct.csv" VAR("rct_we")))
    errset(mtxDump("/home/mseminario2/vestarv/implementations/asic/castalia/analog/data/raw/px_grid_stb__pt51__grid_rf.csv" VAR("rf")))
    errset(mtxDump("/home/mseminario2/vestarv/implementations/asic/castalia/analog/data/raw/px_grid_stb__pt51__stb_aol_db.csv" value(dB20(getData("loopGain" ?result "stb")) 1)))
    errset(mtxDump("/home/mseminario2/vestarv/implementations/asic/castalia/analog/data/raw/px_grid_stb__pt51__stb_pm.csv" (phaseMargin(getData("loopGain" ?result "stb")) + 180)))
  )
)

;; ---- corner 52 (ff52) / test px_grid_noise
when(isDir("/home/mseminario2/chips/castalia/ic/.simulation/castalia/tb_anatop_pixel/maestro/results/maestro/Interactive.20/52/PotTiaTB/psf")
  openResults("/home/mseminario2/chips/castalia/ic/.simulation/castalia/tb_anatop_pixel/maestro/results/maestro/Interactive.20/52/PotTiaTB/psf")
  when(member('noise results())
    selectResult('noise)
    mtxP = outfile("/home/mseminario2/vestarv/implementations/asic/castalia/analog/data/raw/px_grid_noise__ff52.meta" "w")
    fprintf(mtxP "sweep %%L\n" car(errset(sweepNames())))
    close(mtxP)
    errset(mtxDump("/home/mseminario2/vestarv/implementations/asic/castalia/analog/data/raw/px_grid_noise__ff52__grid_cdl.csv" VAR("cdl_we")))
    errset(mtxDump("/home/mseminario2/vestarv/implementations/asic/castalia/analog/data/raw/px_grid_noise__ff52__grid_rct.csv" VAR("rct_we")))
    errset(mtxDump("/home/mseminario2/vestarv/implementations/asic/castalia/analog/data/raw/px_grid_noise__ff52__grid_rf.csv" VAR("rf")))
    errset(mtxDump("/home/mseminario2/vestarv/implementations/asic/castalia/analog/data/raw/px_grid_noise__ff52__in_rma.csv" (rmsNoise(0.1 1000.0) / VAR("rf"))))
    errset(mtxDump("/home/mseminario2/vestarv/implementations/asic/castalia/analog/data/raw/px_grid_noise__ff52__vn_out.csv" rmsNoise(0.1 1000.0)))
  )
)

;; ---- corner 52 (ff52) / test px_grid_stb
when(isDir("/home/mseminario2/chips/castalia/ic/.simulation/castalia/tb_anatop_pixel/maestro/results/maestro/Interactive.20/52/PotTiaTB/psf")
  openResults("/home/mseminario2/chips/castalia/ic/.simulation/castalia/tb_anatop_pixel/maestro/results/maestro/Interactive.20/52/PotTiaTB/psf")
  when(member('stb results())
    selectResult('stb)
    mtxP = outfile("/home/mseminario2/vestarv/implementations/asic/castalia/analog/data/raw/px_grid_stb__ff52.meta" "w")
    fprintf(mtxP "sweep %%L\n" car(errset(sweepNames())))
    close(mtxP)
    errset(mtxDump("/home/mseminario2/vestarv/implementations/asic/castalia/analog/data/raw/px_grid_stb__ff52__grid_cdl.csv" VAR("cdl_we")))
    errset(mtxDump("/home/mseminario2/vestarv/implementations/asic/castalia/analog/data/raw/px_grid_stb__ff52__grid_rct.csv" VAR("rct_we")))
    errset(mtxDump("/home/mseminario2/vestarv/implementations/asic/castalia/analog/data/raw/px_grid_stb__ff52__grid_rf.csv" VAR("rf")))
    errset(mtxDump("/home/mseminario2/vestarv/implementations/asic/castalia/analog/data/raw/px_grid_stb__ff52__stb_aol_db.csv" value(dB20(getData("loopGain" ?result "stb")) 1)))
    errset(mtxDump("/home/mseminario2/vestarv/implementations/asic/castalia/analog/data/raw/px_grid_stb__ff52__stb_pm.csv" (phaseMargin(getData("loopGain" ?result "stb")) + 180)))
  )
)

;; ---- corner 53 (fs53) / test px_grid_noise
when(isDir("/home/mseminario2/chips/castalia/ic/.simulation/castalia/tb_anatop_pixel/maestro/results/maestro/Interactive.20/53/PotTiaTB/psf")
  openResults("/home/mseminario2/chips/castalia/ic/.simulation/castalia/tb_anatop_pixel/maestro/results/maestro/Interactive.20/53/PotTiaTB/psf")
  when(member('noise results())
    selectResult('noise)
    mtxP = outfile("/home/mseminario2/vestarv/implementations/asic/castalia/analog/data/raw/px_grid_noise__fs53.meta" "w")
    fprintf(mtxP "sweep %%L\n" car(errset(sweepNames())))
    close(mtxP)
    errset(mtxDump("/home/mseminario2/vestarv/implementations/asic/castalia/analog/data/raw/px_grid_noise__fs53__grid_cdl.csv" VAR("cdl_we")))
    errset(mtxDump("/home/mseminario2/vestarv/implementations/asic/castalia/analog/data/raw/px_grid_noise__fs53__grid_rct.csv" VAR("rct_we")))
    errset(mtxDump("/home/mseminario2/vestarv/implementations/asic/castalia/analog/data/raw/px_grid_noise__fs53__grid_rf.csv" VAR("rf")))
    errset(mtxDump("/home/mseminario2/vestarv/implementations/asic/castalia/analog/data/raw/px_grid_noise__fs53__in_rma.csv" (rmsNoise(0.1 1000.0) / VAR("rf"))))
    errset(mtxDump("/home/mseminario2/vestarv/implementations/asic/castalia/analog/data/raw/px_grid_noise__fs53__vn_out.csv" rmsNoise(0.1 1000.0)))
  )
)

;; ---- corner 53 (fs53) / test px_grid_stb
when(isDir("/home/mseminario2/chips/castalia/ic/.simulation/castalia/tb_anatop_pixel/maestro/results/maestro/Interactive.20/53/PotTiaTB/psf")
  openResults("/home/mseminario2/chips/castalia/ic/.simulation/castalia/tb_anatop_pixel/maestro/results/maestro/Interactive.20/53/PotTiaTB/psf")
  when(member('stb results())
    selectResult('stb)
    mtxP = outfile("/home/mseminario2/vestarv/implementations/asic/castalia/analog/data/raw/px_grid_stb__fs53.meta" "w")
    fprintf(mtxP "sweep %%L\n" car(errset(sweepNames())))
    close(mtxP)
    errset(mtxDump("/home/mseminario2/vestarv/implementations/asic/castalia/analog/data/raw/px_grid_stb__fs53__grid_cdl.csv" VAR("cdl_we")))
    errset(mtxDump("/home/mseminario2/vestarv/implementations/asic/castalia/analog/data/raw/px_grid_stb__fs53__grid_rct.csv" VAR("rct_we")))
    errset(mtxDump("/home/mseminario2/vestarv/implementations/asic/castalia/analog/data/raw/px_grid_stb__fs53__grid_rf.csv" VAR("rf")))
    errset(mtxDump("/home/mseminario2/vestarv/implementations/asic/castalia/analog/data/raw/px_grid_stb__fs53__stb_aol_db.csv" value(dB20(getData("loopGain" ?result "stb")) 1)))
    errset(mtxDump("/home/mseminario2/vestarv/implementations/asic/castalia/analog/data/raw/px_grid_stb__fs53__stb_pm.csv" (phaseMargin(getData("loopGain" ?result "stb")) + 180)))
  )
)

;; ---- corner 54 (sf54) / test px_grid_noise
when(isDir("/home/mseminario2/chips/castalia/ic/.simulation/castalia/tb_anatop_pixel/maestro/results/maestro/Interactive.20/54/PotTiaTB/psf")
  openResults("/home/mseminario2/chips/castalia/ic/.simulation/castalia/tb_anatop_pixel/maestro/results/maestro/Interactive.20/54/PotTiaTB/psf")
  when(member('noise results())
    selectResult('noise)
    mtxP = outfile("/home/mseminario2/vestarv/implementations/asic/castalia/analog/data/raw/px_grid_noise__sf54.meta" "w")
    fprintf(mtxP "sweep %%L\n" car(errset(sweepNames())))
    close(mtxP)
    errset(mtxDump("/home/mseminario2/vestarv/implementations/asic/castalia/analog/data/raw/px_grid_noise__sf54__grid_cdl.csv" VAR("cdl_we")))
    errset(mtxDump("/home/mseminario2/vestarv/implementations/asic/castalia/analog/data/raw/px_grid_noise__sf54__grid_rct.csv" VAR("rct_we")))
    errset(mtxDump("/home/mseminario2/vestarv/implementations/asic/castalia/analog/data/raw/px_grid_noise__sf54__grid_rf.csv" VAR("rf")))
    errset(mtxDump("/home/mseminario2/vestarv/implementations/asic/castalia/analog/data/raw/px_grid_noise__sf54__in_rma.csv" (rmsNoise(0.1 1000.0) / VAR("rf"))))
    errset(mtxDump("/home/mseminario2/vestarv/implementations/asic/castalia/analog/data/raw/px_grid_noise__sf54__vn_out.csv" rmsNoise(0.1 1000.0)))
  )
)

;; ---- corner 54 (sf54) / test px_grid_stb
when(isDir("/home/mseminario2/chips/castalia/ic/.simulation/castalia/tb_anatop_pixel/maestro/results/maestro/Interactive.20/54/PotTiaTB/psf")
  openResults("/home/mseminario2/chips/castalia/ic/.simulation/castalia/tb_anatop_pixel/maestro/results/maestro/Interactive.20/54/PotTiaTB/psf")
  when(member('stb results())
    selectResult('stb)
    mtxP = outfile("/home/mseminario2/vestarv/implementations/asic/castalia/analog/data/raw/px_grid_stb__sf54.meta" "w")
    fprintf(mtxP "sweep %%L\n" car(errset(sweepNames())))
    close(mtxP)
    errset(mtxDump("/home/mseminario2/vestarv/implementations/asic/castalia/analog/data/raw/px_grid_stb__sf54__grid_cdl.csv" VAR("cdl_we")))
    errset(mtxDump("/home/mseminario2/vestarv/implementations/asic/castalia/analog/data/raw/px_grid_stb__sf54__grid_rct.csv" VAR("rct_we")))
    errset(mtxDump("/home/mseminario2/vestarv/implementations/asic/castalia/analog/data/raw/px_grid_stb__sf54__grid_rf.csv" VAR("rf")))
    errset(mtxDump("/home/mseminario2/vestarv/implementations/asic/castalia/analog/data/raw/px_grid_stb__sf54__stb_aol_db.csv" value(dB20(getData("loopGain" ?result "stb")) 1)))
    errset(mtxDump("/home/mseminario2/vestarv/implementations/asic/castalia/analog/data/raw/px_grid_stb__sf54__stb_pm.csv" (phaseMargin(getData("loopGain" ?result "stb")) + 180)))
  )
)

;; ---- corner 55 (ss55) / test px_grid_noise
when(isDir("/home/mseminario2/chips/castalia/ic/.simulation/castalia/tb_anatop_pixel/maestro/results/maestro/Interactive.20/55/PotTiaTB/psf")
  openResults("/home/mseminario2/chips/castalia/ic/.simulation/castalia/tb_anatop_pixel/maestro/results/maestro/Interactive.20/55/PotTiaTB/psf")
  when(member('noise results())
    selectResult('noise)
    mtxP = outfile("/home/mseminario2/vestarv/implementations/asic/castalia/analog/data/raw/px_grid_noise__ss55.meta" "w")
    fprintf(mtxP "sweep %%L\n" car(errset(sweepNames())))
    close(mtxP)
    errset(mtxDump("/home/mseminario2/vestarv/implementations/asic/castalia/analog/data/raw/px_grid_noise__ss55__grid_cdl.csv" VAR("cdl_we")))
    errset(mtxDump("/home/mseminario2/vestarv/implementations/asic/castalia/analog/data/raw/px_grid_noise__ss55__grid_rct.csv" VAR("rct_we")))
    errset(mtxDump("/home/mseminario2/vestarv/implementations/asic/castalia/analog/data/raw/px_grid_noise__ss55__grid_rf.csv" VAR("rf")))
    errset(mtxDump("/home/mseminario2/vestarv/implementations/asic/castalia/analog/data/raw/px_grid_noise__ss55__in_rma.csv" (rmsNoise(0.1 1000.0) / VAR("rf"))))
    errset(mtxDump("/home/mseminario2/vestarv/implementations/asic/castalia/analog/data/raw/px_grid_noise__ss55__vn_out.csv" rmsNoise(0.1 1000.0)))
  )
)

;; ---- corner 55 (ss55) / test px_grid_stb
when(isDir("/home/mseminario2/chips/castalia/ic/.simulation/castalia/tb_anatop_pixel/maestro/results/maestro/Interactive.20/55/PotTiaTB/psf")
  openResults("/home/mseminario2/chips/castalia/ic/.simulation/castalia/tb_anatop_pixel/maestro/results/maestro/Interactive.20/55/PotTiaTB/psf")
  when(member('stb results())
    selectResult('stb)
    mtxP = outfile("/home/mseminario2/vestarv/implementations/asic/castalia/analog/data/raw/px_grid_stb__ss55.meta" "w")
    fprintf(mtxP "sweep %%L\n" car(errset(sweepNames())))
    close(mtxP)
    errset(mtxDump("/home/mseminario2/vestarv/implementations/asic/castalia/analog/data/raw/px_grid_stb__ss55__grid_cdl.csv" VAR("cdl_we")))
    errset(mtxDump("/home/mseminario2/vestarv/implementations/asic/castalia/analog/data/raw/px_grid_stb__ss55__grid_rct.csv" VAR("rct_we")))
    errset(mtxDump("/home/mseminario2/vestarv/implementations/asic/castalia/analog/data/raw/px_grid_stb__ss55__grid_rf.csv" VAR("rf")))
    errset(mtxDump("/home/mseminario2/vestarv/implementations/asic/castalia/analog/data/raw/px_grid_stb__ss55__stb_aol_db.csv" value(dB20(getData("loopGain" ?result "stb")) 1)))
    errset(mtxDump("/home/mseminario2/vestarv/implementations/asic/castalia/analog/data/raw/px_grid_stb__ss55__stb_pm.csv" (phaseMargin(getData("loopGain" ?result "stb")) + 180)))
  )
)

;; ---- corner 56 (pt56) / test px_grid_noise
when(isDir("/home/mseminario2/chips/castalia/ic/.simulation/castalia/tb_anatop_pixel/maestro/results/maestro/Interactive.20/56/PotTiaTB/psf")
  openResults("/home/mseminario2/chips/castalia/ic/.simulation/castalia/tb_anatop_pixel/maestro/results/maestro/Interactive.20/56/PotTiaTB/psf")
  when(member('noise results())
    selectResult('noise)
    mtxP = outfile("/home/mseminario2/vestarv/implementations/asic/castalia/analog/data/raw/px_grid_noise__pt56.meta" "w")
    fprintf(mtxP "sweep %%L\n" car(errset(sweepNames())))
    close(mtxP)
    errset(mtxDump("/home/mseminario2/vestarv/implementations/asic/castalia/analog/data/raw/px_grid_noise__pt56__grid_cdl.csv" VAR("cdl_we")))
    errset(mtxDump("/home/mseminario2/vestarv/implementations/asic/castalia/analog/data/raw/px_grid_noise__pt56__grid_rct.csv" VAR("rct_we")))
    errset(mtxDump("/home/mseminario2/vestarv/implementations/asic/castalia/analog/data/raw/px_grid_noise__pt56__grid_rf.csv" VAR("rf")))
    errset(mtxDump("/home/mseminario2/vestarv/implementations/asic/castalia/analog/data/raw/px_grid_noise__pt56__in_rma.csv" (rmsNoise(0.1 1000.0) / VAR("rf"))))
    errset(mtxDump("/home/mseminario2/vestarv/implementations/asic/castalia/analog/data/raw/px_grid_noise__pt56__vn_out.csv" rmsNoise(0.1 1000.0)))
  )
)

;; ---- corner 56 (pt56) / test px_grid_stb
when(isDir("/home/mseminario2/chips/castalia/ic/.simulation/castalia/tb_anatop_pixel/maestro/results/maestro/Interactive.20/56/PotTiaTB/psf")
  openResults("/home/mseminario2/chips/castalia/ic/.simulation/castalia/tb_anatop_pixel/maestro/results/maestro/Interactive.20/56/PotTiaTB/psf")
  when(member('stb results())
    selectResult('stb)
    mtxP = outfile("/home/mseminario2/vestarv/implementations/asic/castalia/analog/data/raw/px_grid_stb__pt56.meta" "w")
    fprintf(mtxP "sweep %%L\n" car(errset(sweepNames())))
    close(mtxP)
    errset(mtxDump("/home/mseminario2/vestarv/implementations/asic/castalia/analog/data/raw/px_grid_stb__pt56__grid_cdl.csv" VAR("cdl_we")))
    errset(mtxDump("/home/mseminario2/vestarv/implementations/asic/castalia/analog/data/raw/px_grid_stb__pt56__grid_rct.csv" VAR("rct_we")))
    errset(mtxDump("/home/mseminario2/vestarv/implementations/asic/castalia/analog/data/raw/px_grid_stb__pt56__grid_rf.csv" VAR("rf")))
    errset(mtxDump("/home/mseminario2/vestarv/implementations/asic/castalia/analog/data/raw/px_grid_stb__pt56__stb_aol_db.csv" value(dB20(getData("loopGain" ?result "stb")) 1)))
    errset(mtxDump("/home/mseminario2/vestarv/implementations/asic/castalia/analog/data/raw/px_grid_stb__pt56__stb_pm.csv" (phaseMargin(getData("loopGain" ?result "stb")) + 180)))
  )
)

;; ---- corner 57 (ff57) / test px_grid_noise
when(isDir("/home/mseminario2/chips/castalia/ic/.simulation/castalia/tb_anatop_pixel/maestro/results/maestro/Interactive.20/57/PotTiaTB/psf")
  openResults("/home/mseminario2/chips/castalia/ic/.simulation/castalia/tb_anatop_pixel/maestro/results/maestro/Interactive.20/57/PotTiaTB/psf")
  when(member('noise results())
    selectResult('noise)
    mtxP = outfile("/home/mseminario2/vestarv/implementations/asic/castalia/analog/data/raw/px_grid_noise__ff57.meta" "w")
    fprintf(mtxP "sweep %%L\n" car(errset(sweepNames())))
    close(mtxP)
    errset(mtxDump("/home/mseminario2/vestarv/implementations/asic/castalia/analog/data/raw/px_grid_noise__ff57__grid_cdl.csv" VAR("cdl_we")))
    errset(mtxDump("/home/mseminario2/vestarv/implementations/asic/castalia/analog/data/raw/px_grid_noise__ff57__grid_rct.csv" VAR("rct_we")))
    errset(mtxDump("/home/mseminario2/vestarv/implementations/asic/castalia/analog/data/raw/px_grid_noise__ff57__grid_rf.csv" VAR("rf")))
    errset(mtxDump("/home/mseminario2/vestarv/implementations/asic/castalia/analog/data/raw/px_grid_noise__ff57__in_rma.csv" (rmsNoise(0.1 1000.0) / VAR("rf"))))
    errset(mtxDump("/home/mseminario2/vestarv/implementations/asic/castalia/analog/data/raw/px_grid_noise__ff57__vn_out.csv" rmsNoise(0.1 1000.0)))
  )
)

;; ---- corner 57 (ff57) / test px_grid_stb
when(isDir("/home/mseminario2/chips/castalia/ic/.simulation/castalia/tb_anatop_pixel/maestro/results/maestro/Interactive.20/57/PotTiaTB/psf")
  openResults("/home/mseminario2/chips/castalia/ic/.simulation/castalia/tb_anatop_pixel/maestro/results/maestro/Interactive.20/57/PotTiaTB/psf")
  when(member('stb results())
    selectResult('stb)
    mtxP = outfile("/home/mseminario2/vestarv/implementations/asic/castalia/analog/data/raw/px_grid_stb__ff57.meta" "w")
    fprintf(mtxP "sweep %%L\n" car(errset(sweepNames())))
    close(mtxP)
    errset(mtxDump("/home/mseminario2/vestarv/implementations/asic/castalia/analog/data/raw/px_grid_stb__ff57__grid_cdl.csv" VAR("cdl_we")))
    errset(mtxDump("/home/mseminario2/vestarv/implementations/asic/castalia/analog/data/raw/px_grid_stb__ff57__grid_rct.csv" VAR("rct_we")))
    errset(mtxDump("/home/mseminario2/vestarv/implementations/asic/castalia/analog/data/raw/px_grid_stb__ff57__grid_rf.csv" VAR("rf")))
    errset(mtxDump("/home/mseminario2/vestarv/implementations/asic/castalia/analog/data/raw/px_grid_stb__ff57__stb_aol_db.csv" value(dB20(getData("loopGain" ?result "stb")) 1)))
    errset(mtxDump("/home/mseminario2/vestarv/implementations/asic/castalia/analog/data/raw/px_grid_stb__ff57__stb_pm.csv" (phaseMargin(getData("loopGain" ?result "stb")) + 180)))
  )
)

;; ---- corner 58 (fs58) / test px_grid_noise
when(isDir("/home/mseminario2/chips/castalia/ic/.simulation/castalia/tb_anatop_pixel/maestro/results/maestro/Interactive.20/58/PotTiaTB/psf")
  openResults("/home/mseminario2/chips/castalia/ic/.simulation/castalia/tb_anatop_pixel/maestro/results/maestro/Interactive.20/58/PotTiaTB/psf")
  when(member('noise results())
    selectResult('noise)
    mtxP = outfile("/home/mseminario2/vestarv/implementations/asic/castalia/analog/data/raw/px_grid_noise__fs58.meta" "w")
    fprintf(mtxP "sweep %%L\n" car(errset(sweepNames())))
    close(mtxP)
    errset(mtxDump("/home/mseminario2/vestarv/implementations/asic/castalia/analog/data/raw/px_grid_noise__fs58__grid_cdl.csv" VAR("cdl_we")))
    errset(mtxDump("/home/mseminario2/vestarv/implementations/asic/castalia/analog/data/raw/px_grid_noise__fs58__grid_rct.csv" VAR("rct_we")))
    errset(mtxDump("/home/mseminario2/vestarv/implementations/asic/castalia/analog/data/raw/px_grid_noise__fs58__grid_rf.csv" VAR("rf")))
    errset(mtxDump("/home/mseminario2/vestarv/implementations/asic/castalia/analog/data/raw/px_grid_noise__fs58__in_rma.csv" (rmsNoise(0.1 1000.0) / VAR("rf"))))
    errset(mtxDump("/home/mseminario2/vestarv/implementations/asic/castalia/analog/data/raw/px_grid_noise__fs58__vn_out.csv" rmsNoise(0.1 1000.0)))
  )
)

;; ---- corner 58 (fs58) / test px_grid_stb
when(isDir("/home/mseminario2/chips/castalia/ic/.simulation/castalia/tb_anatop_pixel/maestro/results/maestro/Interactive.20/58/PotTiaTB/psf")
  openResults("/home/mseminario2/chips/castalia/ic/.simulation/castalia/tb_anatop_pixel/maestro/results/maestro/Interactive.20/58/PotTiaTB/psf")
  when(member('stb results())
    selectResult('stb)
    mtxP = outfile("/home/mseminario2/vestarv/implementations/asic/castalia/analog/data/raw/px_grid_stb__fs58.meta" "w")
    fprintf(mtxP "sweep %%L\n" car(errset(sweepNames())))
    close(mtxP)
    errset(mtxDump("/home/mseminario2/vestarv/implementations/asic/castalia/analog/data/raw/px_grid_stb__fs58__grid_cdl.csv" VAR("cdl_we")))
    errset(mtxDump("/home/mseminario2/vestarv/implementations/asic/castalia/analog/data/raw/px_grid_stb__fs58__grid_rct.csv" VAR("rct_we")))
    errset(mtxDump("/home/mseminario2/vestarv/implementations/asic/castalia/analog/data/raw/px_grid_stb__fs58__grid_rf.csv" VAR("rf")))
    errset(mtxDump("/home/mseminario2/vestarv/implementations/asic/castalia/analog/data/raw/px_grid_stb__fs58__stb_aol_db.csv" value(dB20(getData("loopGain" ?result "stb")) 1)))
    errset(mtxDump("/home/mseminario2/vestarv/implementations/asic/castalia/analog/data/raw/px_grid_stb__fs58__stb_pm.csv" (phaseMargin(getData("loopGain" ?result "stb")) + 180)))
  )
)

;; ---- corner 59 (sf59) / test px_grid_noise
when(isDir("/home/mseminario2/chips/castalia/ic/.simulation/castalia/tb_anatop_pixel/maestro/results/maestro/Interactive.20/59/PotTiaTB/psf")
  openResults("/home/mseminario2/chips/castalia/ic/.simulation/castalia/tb_anatop_pixel/maestro/results/maestro/Interactive.20/59/PotTiaTB/psf")
  when(member('noise results())
    selectResult('noise)
    mtxP = outfile("/home/mseminario2/vestarv/implementations/asic/castalia/analog/data/raw/px_grid_noise__sf59.meta" "w")
    fprintf(mtxP "sweep %%L\n" car(errset(sweepNames())))
    close(mtxP)
    errset(mtxDump("/home/mseminario2/vestarv/implementations/asic/castalia/analog/data/raw/px_grid_noise__sf59__grid_cdl.csv" VAR("cdl_we")))
    errset(mtxDump("/home/mseminario2/vestarv/implementations/asic/castalia/analog/data/raw/px_grid_noise__sf59__grid_rct.csv" VAR("rct_we")))
    errset(mtxDump("/home/mseminario2/vestarv/implementations/asic/castalia/analog/data/raw/px_grid_noise__sf59__grid_rf.csv" VAR("rf")))
    errset(mtxDump("/home/mseminario2/vestarv/implementations/asic/castalia/analog/data/raw/px_grid_noise__sf59__in_rma.csv" (rmsNoise(0.1 1000.0) / VAR("rf"))))
    errset(mtxDump("/home/mseminario2/vestarv/implementations/asic/castalia/analog/data/raw/px_grid_noise__sf59__vn_out.csv" rmsNoise(0.1 1000.0)))
  )
)

;; ---- corner 59 (sf59) / test px_grid_stb
when(isDir("/home/mseminario2/chips/castalia/ic/.simulation/castalia/tb_anatop_pixel/maestro/results/maestro/Interactive.20/59/PotTiaTB/psf")
  openResults("/home/mseminario2/chips/castalia/ic/.simulation/castalia/tb_anatop_pixel/maestro/results/maestro/Interactive.20/59/PotTiaTB/psf")
  when(member('stb results())
    selectResult('stb)
    mtxP = outfile("/home/mseminario2/vestarv/implementations/asic/castalia/analog/data/raw/px_grid_stb__sf59.meta" "w")
    fprintf(mtxP "sweep %%L\n" car(errset(sweepNames())))
    close(mtxP)
    errset(mtxDump("/home/mseminario2/vestarv/implementations/asic/castalia/analog/data/raw/px_grid_stb__sf59__grid_cdl.csv" VAR("cdl_we")))
    errset(mtxDump("/home/mseminario2/vestarv/implementations/asic/castalia/analog/data/raw/px_grid_stb__sf59__grid_rct.csv" VAR("rct_we")))
    errset(mtxDump("/home/mseminario2/vestarv/implementations/asic/castalia/analog/data/raw/px_grid_stb__sf59__grid_rf.csv" VAR("rf")))
    errset(mtxDump("/home/mseminario2/vestarv/implementations/asic/castalia/analog/data/raw/px_grid_stb__sf59__stb_aol_db.csv" value(dB20(getData("loopGain" ?result "stb")) 1)))
    errset(mtxDump("/home/mseminario2/vestarv/implementations/asic/castalia/analog/data/raw/px_grid_stb__sf59__stb_pm.csv" (phaseMargin(getData("loopGain" ?result "stb")) + 180)))
  )
)

;; ---- corner 60 (ss60) / test px_grid_noise
when(isDir("/home/mseminario2/chips/castalia/ic/.simulation/castalia/tb_anatop_pixel/maestro/results/maestro/Interactive.20/60/PotTiaTB/psf")
  openResults("/home/mseminario2/chips/castalia/ic/.simulation/castalia/tb_anatop_pixel/maestro/results/maestro/Interactive.20/60/PotTiaTB/psf")
  when(member('noise results())
    selectResult('noise)
    mtxP = outfile("/home/mseminario2/vestarv/implementations/asic/castalia/analog/data/raw/px_grid_noise__ss60.meta" "w")
    fprintf(mtxP "sweep %%L\n" car(errset(sweepNames())))
    close(mtxP)
    errset(mtxDump("/home/mseminario2/vestarv/implementations/asic/castalia/analog/data/raw/px_grid_noise__ss60__grid_cdl.csv" VAR("cdl_we")))
    errset(mtxDump("/home/mseminario2/vestarv/implementations/asic/castalia/analog/data/raw/px_grid_noise__ss60__grid_rct.csv" VAR("rct_we")))
    errset(mtxDump("/home/mseminario2/vestarv/implementations/asic/castalia/analog/data/raw/px_grid_noise__ss60__grid_rf.csv" VAR("rf")))
    errset(mtxDump("/home/mseminario2/vestarv/implementations/asic/castalia/analog/data/raw/px_grid_noise__ss60__in_rma.csv" (rmsNoise(0.1 1000.0) / VAR("rf"))))
    errset(mtxDump("/home/mseminario2/vestarv/implementations/asic/castalia/analog/data/raw/px_grid_noise__ss60__vn_out.csv" rmsNoise(0.1 1000.0)))
  )
)

;; ---- corner 60 (ss60) / test px_grid_stb
when(isDir("/home/mseminario2/chips/castalia/ic/.simulation/castalia/tb_anatop_pixel/maestro/results/maestro/Interactive.20/60/PotTiaTB/psf")
  openResults("/home/mseminario2/chips/castalia/ic/.simulation/castalia/tb_anatop_pixel/maestro/results/maestro/Interactive.20/60/PotTiaTB/psf")
  when(member('stb results())
    selectResult('stb)
    mtxP = outfile("/home/mseminario2/vestarv/implementations/asic/castalia/analog/data/raw/px_grid_stb__ss60.meta" "w")
    fprintf(mtxP "sweep %%L\n" car(errset(sweepNames())))
    close(mtxP)
    errset(mtxDump("/home/mseminario2/vestarv/implementations/asic/castalia/analog/data/raw/px_grid_stb__ss60__grid_cdl.csv" VAR("cdl_we")))
    errset(mtxDump("/home/mseminario2/vestarv/implementations/asic/castalia/analog/data/raw/px_grid_stb__ss60__grid_rct.csv" VAR("rct_we")))
    errset(mtxDump("/home/mseminario2/vestarv/implementations/asic/castalia/analog/data/raw/px_grid_stb__ss60__grid_rf.csv" VAR("rf")))
    errset(mtxDump("/home/mseminario2/vestarv/implementations/asic/castalia/analog/data/raw/px_grid_stb__ss60__stb_aol_db.csv" value(dB20(getData("loopGain" ?result "stb")) 1)))
    errset(mtxDump("/home/mseminario2/vestarv/implementations/asic/castalia/analog/data/raw/px_grid_stb__ss60__stb_pm.csv" (phaseMargin(getData("loopGain" ?result "stb")) + 180)))
  )
)

printf("MTX_EXTRACT_DONE\n")
exit(0)
