;; generated by maestro2tex -- do not edit
procedure(mtxDump(fname wv)
  let((xs ys n p)
    p = outfile(fname "w")
    cond(
      (null(wv) fprintf(p "#nil\n"))
      (drIsWaveform(wv)
        xs = drGetWaveformXVec(wv)
        ys = drGetWaveformYVec(wv)
        n = drVectorLength(xs)
        for(i 0 n-1
          fprintf(p "%.10g %.10g\n" drGetElem(xs i) drGetElem(ys i)))
      )
      (t fprintf(p "#scalar %.10g\n" float(wv)))
    )
    close(p)
    t))

;; ---- corner 1 (tt) / test ab_amp_op
when(isDir("/home/mseminario2/chips/castalia/ic/.simulation/castalia/tb_anatop_tia_amp_ab/maestro/results/maestro/Interactive.14/1/TypOpenLoopTB/psf")
  openResults("/home/mseminario2/chips/castalia/ic/.simulation/castalia/tb_anatop_tia_amp_ab/maestro/results/maestro/Interactive.14/1/TypOpenLoopTB/psf")
  when(member('dcOp results())
    selectResult('dcOp)
    mtxP = outfile("/home/mseminario2/vestarv/implementations/asic/castalia/analog/data/raw/ab_amp_op__tt.meta" "w")
    fprintf(mtxP "sweep %%L\n" car(errset(sweepNames())))
    close(mtxP)
    errset(mtxDump("/home/mseminario2/vestarv/implementations/asic/castalia/analog/data/raw/ab_amp_op__tt__p_opamp.csv" getData("OPAMP:pwr" ?result "dcOp")))
  )
)

;; ---- corner 1 (tt) / test ab_drive_dc
when(isDir("/home/mseminario2/chips/castalia/ic/.simulation/castalia/tb_anatop_tia_amp_ab/maestro/results/maestro/Interactive.14/1/DriveTB/psf")
  openResults("/home/mseminario2/chips/castalia/ic/.simulation/castalia/tb_anatop_tia_amp_ab/maestro/results/maestro/Interactive.14/1/DriveTB/psf")
  when(member('dc results())
    selectResult('dc)
    mtxP = outfile("/home/mseminario2/vestarv/implementations/asic/castalia/analog/data/raw/ab_drive_dc__tt.meta" "w")
    fprintf(mtxP "sweep %%L\n" car(errset(sweepNames())))
    close(mtxP)
    errset(mtxDump("/home/mseminario2/vestarv/implementations/asic/castalia/analog/data/raw/ab_drive_dc__tt__i_sink_50m.csv" abs(cross(abs((VS("/V_OutOL") - VAR("V_CM"))) 0.05 1 "falling"))))
    errset(mtxDump("/home/mseminario2/vestarv/implementations/asic/castalia/analog/data/raw/ab_drive_dc__tt__i_src_50m.csv" cross(abs((VS("/V_OutOL") - VAR("V_CM"))) 0.05 1 "rising")))
  )
)

;; ---- corner 1 (tt) / test ab_tiafb_ac
when(isDir("/home/mseminario2/chips/castalia/ic/.simulation/castalia/tb_anatop_tia_amp_ab/maestro/results/maestro/Interactive.14/1/TiaFbTB/psf")
  openResults("/home/mseminario2/chips/castalia/ic/.simulation/castalia/tb_anatop_tia_amp_ab/maestro/results/maestro/Interactive.14/1/TiaFbTB/psf")
  when(member('ac results())
    selectResult('ac)
    mtxP = outfile("/home/mseminario2/vestarv/implementations/asic/castalia/analog/data/raw/ab_tiafb_ac__tt.meta" "w")
    fprintf(mtxP "sweep %%L\n" car(errset(sweepNames())))
    close(mtxP)
    errset(mtxDump("/home/mseminario2/vestarv/implementations/asic/castalia/analog/data/raw/ab_tiafb_ac__tt__f3db.csv" bandwidth(VF("/V_OUT") 3 "low")))
    errset(mtxDump("/home/mseminario2/vestarv/implementations/asic/castalia/analog/data/raw/ab_tiafb_ac__tt__peaking_db.csv" dB20((ymax(mag(VF("/V_OUT"))) / value(mag(VF("/V_OUT")) 1)))))
    errset(mtxDump("/home/mseminario2/vestarv/implementations/asic/castalia/analog/data/raw/ab_tiafb_ac__tt__zt.csv" mag(VF("/V_OUT"))))
    errset(mtxDump("/home/mseminario2/vestarv/implementations/asic/castalia/analog/data/raw/ab_tiafb_ac__tt__zt0.csv" value(mag(VF("/V_OUT")) 1)))
    errset(mtxDump("/home/mseminario2/vestarv/implementations/asic/castalia/analog/data/raw/ab_tiafb_ac__tt__zt_err.csv" ((value(mag(VF("/V_OUT")) 1) - VAR("rf")) / VAR("rf"))))
  )
)

;; ---- corner 1 (tt) / test ab_tiafb_dc
when(isDir("/home/mseminario2/chips/castalia/ic/.simulation/castalia/tb_anatop_tia_amp_ab/maestro/results/maestro/Interactive.14/1/TiaFbTB/psf")
  openResults("/home/mseminario2/chips/castalia/ic/.simulation/castalia/tb_anatop_tia_amp_ab/maestro/results/maestro/Interactive.14/1/TiaFbTB/psf")
  when(member('dc results())
    selectResult('dc)
    mtxP = outfile("/home/mseminario2/vestarv/implementations/asic/castalia/analog/data/raw/ab_tiafb_dc__tt.meta" "w")
    fprintf(mtxP "sweep %%L\n" car(errset(sweepNames())))
    close(mtxP)
    errset(mtxDump("/home/mseminario2/vestarv/implementations/asic/castalia/analog/data/raw/ab_tiafb_dc__tt__gain_err.csv" (((value(VS("/V_OUT") min(0.9 ((8e-06 * VAR("rf")) / VAR("vfs")))) - value(VS("/V_OUT") (- min(0.9 ((8e-06 * VAR("rf")) / VAR("vfs")))))) / (2 * min(0.9 ((8e-06 * VAR("rf")) / VAR("vfs")))) / VAR("vfs")) - 1)))
    errset(mtxDump("/home/mseminario2/vestarv/implementations/asic/castalia/analog/data/raw/ab_tiafb_dc__tt__inl_lsb.csv" (ymax(abs(clip((VS("/V_OUT") - (value(VS("/V_OUT") (- min(0.9 ((8e-06 * VAR("rf")) / VAR("vfs"))))) + (((value(VS("/V_OUT") min(0.9 ((8e-06 * VAR("rf")) / VAR("vfs")))) - value(VS("/V_OUT") (- min(0.9 ((8e-06 * VAR("rf")) / VAR("vfs")))))) / (2 * min(0.9 ((8e-06 * VAR("rf")) / VAR("vfs"))))) * (xval(VS("/V_OUT")) + min(0.9 ((8e-06 * VAR("rf")) / VAR("vfs"))))))) (- min(0.9 ((8e-06 * VAR("rf")) / VAR("vfs")))) min(0.9 ((8e-06 * VAR("rf")) / VAR("vfs")))))) / 0.002441)))
    errset(mtxDump("/home/mseminario2/vestarv/implementations/asic/castalia/analog/data/raw/ab_tiafb_dc__tt__voff.csv" (value(VS("/V_OUT") 0) - VAR("V_CM"))))
  )
)

;; ---- corner 1 (tt) / test ab_tiafb_noise
when(isDir("/home/mseminario2/chips/castalia/ic/.simulation/castalia/tb_anatop_tia_amp_ab/maestro/results/maestro/Interactive.14/1/TiaFbTB/psf")
  openResults("/home/mseminario2/chips/castalia/ic/.simulation/castalia/tb_anatop_tia_amp_ab/maestro/results/maestro/Interactive.14/1/TiaFbTB/psf")
  when(member('noise results())
    selectResult('noise)
    mtxP = outfile("/home/mseminario2/vestarv/implementations/asic/castalia/analog/data/raw/ab_tiafb_noise__tt.meta" "w")
    fprintf(mtxP "sweep %%L\n" car(errset(sweepNames())))
    close(mtxP)
    errset(mtxDump("/home/mseminario2/vestarv/implementations/asic/castalia/analog/data/raw/ab_tiafb_noise__tt__in_rms_10.csv" (rmsNoise(0.1 10) / VAR("rf"))))
    errset(mtxDump("/home/mseminario2/vestarv/implementations/asic/castalia/analog/data/raw/ab_tiafb_noise__tt__in_rms_100.csv" (rmsNoise(0.1 100) / VAR("rf"))))
    errset(mtxDump("/home/mseminario2/vestarv/implementations/asic/castalia/analog/data/raw/ab_tiafb_noise__tt__in_rms_1k.csv" (rmsNoise(0.1 1000.0) / VAR("rf"))))
    errset(mtxDump("/home/mseminario2/vestarv/implementations/asic/castalia/analog/data/raw/ab_tiafb_noise__tt__vn_out.csv" rmsNoise(0.1 1000.0)))
  )
)

;; ---- corner 1 (tt) / test ab_tiafb_stb
when(isDir("/home/mseminario2/chips/castalia/ic/.simulation/castalia/tb_anatop_tia_amp_ab/maestro/results/maestro/Interactive.14/1/TiaFbTB/psf")
  openResults("/home/mseminario2/chips/castalia/ic/.simulation/castalia/tb_anatop_tia_amp_ab/maestro/results/maestro/Interactive.14/1/TiaFbTB/psf")
  when(member('stb results())
    selectResult('stb)
    mtxP = outfile("/home/mseminario2/vestarv/implementations/asic/castalia/analog/data/raw/ab_tiafb_stb__tt.meta" "w")
    fprintf(mtxP "sweep %%L\n" car(errset(sweepNames())))
    close(mtxP)
    errset(mtxDump("/home/mseminario2/vestarv/implementations/asic/castalia/analog/data/raw/ab_tiafb_stb__tt__lg_db.csv" dB20(getData("loopGain" ?result "stb"))))
    errset(mtxDump("/home/mseminario2/vestarv/implementations/asic/castalia/analog/data/raw/ab_tiafb_stb__tt__stb_aol_db.csv" ymax(dB20(getData("loopGain" ?result "stb")))))
    errset(mtxDump("/home/mseminario2/vestarv/implementations/asic/castalia/analog/data/raw/ab_tiafb_stb__tt__stb_fx.csv" cross(dB20(getData("loopGain" ?result "stb")) 0 1 "falling")))
    errset(mtxDump("/home/mseminario2/vestarv/implementations/asic/castalia/analog/data/raw/ab_tiafb_stb__tt__stb_gm.csv" (- value(dB20(getData("loopGain" ?result "stb")) cross(clip(phase(getData("loopGain" ?result "stb")) cross(dB20(getData("loopGain" ?result "stb")) 0 1 "falling") 100000000) 0 1 "falling")))))
    errset(mtxDump("/home/mseminario2/vestarv/implementations/asic/castalia/analog/data/raw/ab_tiafb_stb__tt__stb_pm.csv" value(phase(getData("loopGain" ?result "stb")) cross(dB20(getData("loopGain" ?result "stb")) 0 1 "falling"))))
  )
)

;; ---- corner 1 (tt) / test ab_unity_stb
when(isDir("/home/mseminario2/chips/castalia/ic/.simulation/castalia/tb_anatop_tia_amp_ab/maestro/results/maestro/Interactive.14/1/UnityFeedbackTB/psf")
  openResults("/home/mseminario2/chips/castalia/ic/.simulation/castalia/tb_anatop_tia_amp_ab/maestro/results/maestro/Interactive.14/1/UnityFeedbackTB/psf")
  when(member('stb results())
    selectResult('stb)
    mtxP = outfile("/home/mseminario2/vestarv/implementations/asic/castalia/analog/data/raw/ab_unity_stb__tt.meta" "w")
    fprintf(mtxP "sweep %%L\n" car(errset(sweepNames())))
    close(mtxP)
    errset(mtxDump("/home/mseminario2/vestarv/implementations/asic/castalia/analog/data/raw/ab_unity_stb__tt__uf_aol_db.csv" ymax(dB20(getData("loopGain" ?result "stb")))))
    errset(mtxDump("/home/mseminario2/vestarv/implementations/asic/castalia/analog/data/raw/ab_unity_stb__tt__uf_gm.csv" (- value(dB20(getData("loopGain" ?result "stb")) cross(phase(getData("loopGain" ?result "stb")) 0 1 "falling")))))
    errset(mtxDump("/home/mseminario2/vestarv/implementations/asic/castalia/analog/data/raw/ab_unity_stb__tt__uf_pm.csv" value(phase(getData("loopGain" ?result "stb")) cross(dB20(getData("loopGain" ?result "stb")) 0 1 "falling"))))
    errset(mtxDump("/home/mseminario2/vestarv/implementations/asic/castalia/analog/data/raw/ab_unity_stb__tt__uf_ugf.csv" cross(dB20(getData("loopGain" ?result "stb")) 0 1 "falling")))
  )
)

;; ---- corner 2 (ff) / test ab_amp_op
when(isDir("/home/mseminario2/chips/castalia/ic/.simulation/castalia/tb_anatop_tia_amp_ab/maestro/results/maestro/Interactive.14/2/TypOpenLoopTB/psf")
  openResults("/home/mseminario2/chips/castalia/ic/.simulation/castalia/tb_anatop_tia_amp_ab/maestro/results/maestro/Interactive.14/2/TypOpenLoopTB/psf")
  when(member('dcOp results())
    selectResult('dcOp)
    mtxP = outfile("/home/mseminario2/vestarv/implementations/asic/castalia/analog/data/raw/ab_amp_op__ff.meta" "w")
    fprintf(mtxP "sweep %%L\n" car(errset(sweepNames())))
    close(mtxP)
    errset(mtxDump("/home/mseminario2/vestarv/implementations/asic/castalia/analog/data/raw/ab_amp_op__ff__p_opamp.csv" getData("OPAMP:pwr" ?result "dcOp")))
  )
)

;; ---- corner 2 (ff) / test ab_drive_dc
when(isDir("/home/mseminario2/chips/castalia/ic/.simulation/castalia/tb_anatop_tia_amp_ab/maestro/results/maestro/Interactive.14/2/DriveTB/psf")
  openResults("/home/mseminario2/chips/castalia/ic/.simulation/castalia/tb_anatop_tia_amp_ab/maestro/results/maestro/Interactive.14/2/DriveTB/psf")
  when(member('dc results())
    selectResult('dc)
    mtxP = outfile("/home/mseminario2/vestarv/implementations/asic/castalia/analog/data/raw/ab_drive_dc__ff.meta" "w")
    fprintf(mtxP "sweep %%L\n" car(errset(sweepNames())))
    close(mtxP)
    errset(mtxDump("/home/mseminario2/vestarv/implementations/asic/castalia/analog/data/raw/ab_drive_dc__ff__i_sink_50m.csv" abs(cross(abs((VS("/V_OutOL") - VAR("V_CM"))) 0.05 1 "falling"))))
    errset(mtxDump("/home/mseminario2/vestarv/implementations/asic/castalia/analog/data/raw/ab_drive_dc__ff__i_src_50m.csv" cross(abs((VS("/V_OutOL") - VAR("V_CM"))) 0.05 1 "rising")))
  )
)

;; ---- corner 2 (ff) / test ab_tiafb_ac
when(isDir("/home/mseminario2/chips/castalia/ic/.simulation/castalia/tb_anatop_tia_amp_ab/maestro/results/maestro/Interactive.14/2/TiaFbTB/psf")
  openResults("/home/mseminario2/chips/castalia/ic/.simulation/castalia/tb_anatop_tia_amp_ab/maestro/results/maestro/Interactive.14/2/TiaFbTB/psf")
  when(member('ac results())
    selectResult('ac)
    mtxP = outfile("/home/mseminario2/vestarv/implementations/asic/castalia/analog/data/raw/ab_tiafb_ac__ff.meta" "w")
    fprintf(mtxP "sweep %%L\n" car(errset(sweepNames())))
    close(mtxP)
    errset(mtxDump("/home/mseminario2/vestarv/implementations/asic/castalia/analog/data/raw/ab_tiafb_ac__ff__f3db.csv" bandwidth(VF("/V_OUT") 3 "low")))
    errset(mtxDump("/home/mseminario2/vestarv/implementations/asic/castalia/analog/data/raw/ab_tiafb_ac__ff__peaking_db.csv" dB20((ymax(mag(VF("/V_OUT"))) / value(mag(VF("/V_OUT")) 1)))))
    errset(mtxDump("/home/mseminario2/vestarv/implementations/asic/castalia/analog/data/raw/ab_tiafb_ac__ff__zt.csv" mag(VF("/V_OUT"))))
    errset(mtxDump("/home/mseminario2/vestarv/implementations/asic/castalia/analog/data/raw/ab_tiafb_ac__ff__zt0.csv" value(mag(VF("/V_OUT")) 1)))
    errset(mtxDump("/home/mseminario2/vestarv/implementations/asic/castalia/analog/data/raw/ab_tiafb_ac__ff__zt_err.csv" ((value(mag(VF("/V_OUT")) 1) - VAR("rf")) / VAR("rf"))))
  )
)

;; ---- corner 2 (ff) / test ab_tiafb_dc
when(isDir("/home/mseminario2/chips/castalia/ic/.simulation/castalia/tb_anatop_tia_amp_ab/maestro/results/maestro/Interactive.14/2/TiaFbTB/psf")
  openResults("/home/mseminario2/chips/castalia/ic/.simulation/castalia/tb_anatop_tia_amp_ab/maestro/results/maestro/Interactive.14/2/TiaFbTB/psf")
  when(member('dc results())
    selectResult('dc)
    mtxP = outfile("/home/mseminario2/vestarv/implementations/asic/castalia/analog/data/raw/ab_tiafb_dc__ff.meta" "w")
    fprintf(mtxP "sweep %%L\n" car(errset(sweepNames())))
    close(mtxP)
    errset(mtxDump("/home/mseminario2/vestarv/implementations/asic/castalia/analog/data/raw/ab_tiafb_dc__ff__gain_err.csv" (((value(VS("/V_OUT") min(0.9 ((8e-06 * VAR("rf")) / VAR("vfs")))) - value(VS("/V_OUT") (- min(0.9 ((8e-06 * VAR("rf")) / VAR("vfs")))))) / (2 * min(0.9 ((8e-06 * VAR("rf")) / VAR("vfs")))) / VAR("vfs")) - 1)))
    errset(mtxDump("/home/mseminario2/vestarv/implementations/asic/castalia/analog/data/raw/ab_tiafb_dc__ff__inl_lsb.csv" (ymax(abs(clip((VS("/V_OUT") - (value(VS("/V_OUT") (- min(0.9 ((8e-06 * VAR("rf")) / VAR("vfs"))))) + (((value(VS("/V_OUT") min(0.9 ((8e-06 * VAR("rf")) / VAR("vfs")))) - value(VS("/V_OUT") (- min(0.9 ((8e-06 * VAR("rf")) / VAR("vfs")))))) / (2 * min(0.9 ((8e-06 * VAR("rf")) / VAR("vfs"))))) * (xval(VS("/V_OUT")) + min(0.9 ((8e-06 * VAR("rf")) / VAR("vfs"))))))) (- min(0.9 ((8e-06 * VAR("rf")) / VAR("vfs")))) min(0.9 ((8e-06 * VAR("rf")) / VAR("vfs")))))) / 0.002441)))
    errset(mtxDump("/home/mseminario2/vestarv/implementations/asic/castalia/analog/data/raw/ab_tiafb_dc__ff__voff.csv" (value(VS("/V_OUT") 0) - VAR("V_CM"))))
  )
)

;; ---- corner 2 (ff) / test ab_tiafb_noise
when(isDir("/home/mseminario2/chips/castalia/ic/.simulation/castalia/tb_anatop_tia_amp_ab/maestro/results/maestro/Interactive.14/2/TiaFbTB/psf")
  openResults("/home/mseminario2/chips/castalia/ic/.simulation/castalia/tb_anatop_tia_amp_ab/maestro/results/maestro/Interactive.14/2/TiaFbTB/psf")
  when(member('noise results())
    selectResult('noise)
    mtxP = outfile("/home/mseminario2/vestarv/implementations/asic/castalia/analog/data/raw/ab_tiafb_noise__ff.meta" "w")
    fprintf(mtxP "sweep %%L\n" car(errset(sweepNames())))
    close(mtxP)
    errset(mtxDump("/home/mseminario2/vestarv/implementations/asic/castalia/analog/data/raw/ab_tiafb_noise__ff__in_rms_10.csv" (rmsNoise(0.1 10) / VAR("rf"))))
    errset(mtxDump("/home/mseminario2/vestarv/implementations/asic/castalia/analog/data/raw/ab_tiafb_noise__ff__in_rms_100.csv" (rmsNoise(0.1 100) / VAR("rf"))))
    errset(mtxDump("/home/mseminario2/vestarv/implementations/asic/castalia/analog/data/raw/ab_tiafb_noise__ff__in_rms_1k.csv" (rmsNoise(0.1 1000.0) / VAR("rf"))))
    errset(mtxDump("/home/mseminario2/vestarv/implementations/asic/castalia/analog/data/raw/ab_tiafb_noise__ff__vn_out.csv" rmsNoise(0.1 1000.0)))
  )
)

;; ---- corner 2 (ff) / test ab_tiafb_stb
when(isDir("/home/mseminario2/chips/castalia/ic/.simulation/castalia/tb_anatop_tia_amp_ab/maestro/results/maestro/Interactive.14/2/TiaFbTB/psf")
  openResults("/home/mseminario2/chips/castalia/ic/.simulation/castalia/tb_anatop_tia_amp_ab/maestro/results/maestro/Interactive.14/2/TiaFbTB/psf")
  when(member('stb results())
    selectResult('stb)
    mtxP = outfile("/home/mseminario2/vestarv/implementations/asic/castalia/analog/data/raw/ab_tiafb_stb__ff.meta" "w")
    fprintf(mtxP "sweep %%L\n" car(errset(sweepNames())))
    close(mtxP)
    errset(mtxDump("/home/mseminario2/vestarv/implementations/asic/castalia/analog/data/raw/ab_tiafb_stb__ff__lg_db.csv" dB20(getData("loopGain" ?result "stb"))))
    errset(mtxDump("/home/mseminario2/vestarv/implementations/asic/castalia/analog/data/raw/ab_tiafb_stb__ff__stb_aol_db.csv" ymax(dB20(getData("loopGain" ?result "stb")))))
    errset(mtxDump("/home/mseminario2/vestarv/implementations/asic/castalia/analog/data/raw/ab_tiafb_stb__ff__stb_fx.csv" cross(dB20(getData("loopGain" ?result "stb")) 0 1 "falling")))
    errset(mtxDump("/home/mseminario2/vestarv/implementations/asic/castalia/analog/data/raw/ab_tiafb_stb__ff__stb_gm.csv" (- value(dB20(getData("loopGain" ?result "stb")) cross(clip(phase(getData("loopGain" ?result "stb")) cross(dB20(getData("loopGain" ?result "stb")) 0 1 "falling") 100000000) 0 1 "falling")))))
    errset(mtxDump("/home/mseminario2/vestarv/implementations/asic/castalia/analog/data/raw/ab_tiafb_stb__ff__stb_pm.csv" value(phase(getData("loopGain" ?result "stb")) cross(dB20(getData("loopGain" ?result "stb")) 0 1 "falling"))))
  )
)

;; ---- corner 2 (ff) / test ab_unity_stb
when(isDir("/home/mseminario2/chips/castalia/ic/.simulation/castalia/tb_anatop_tia_amp_ab/maestro/results/maestro/Interactive.14/2/UnityFeedbackTB/psf")
  openResults("/home/mseminario2/chips/castalia/ic/.simulation/castalia/tb_anatop_tia_amp_ab/maestro/results/maestro/Interactive.14/2/UnityFeedbackTB/psf")
  when(member('stb results())
    selectResult('stb)
    mtxP = outfile("/home/mseminario2/vestarv/implementations/asic/castalia/analog/data/raw/ab_unity_stb__ff.meta" "w")
    fprintf(mtxP "sweep %%L\n" car(errset(sweepNames())))
    close(mtxP)
    errset(mtxDump("/home/mseminario2/vestarv/implementations/asic/castalia/analog/data/raw/ab_unity_stb__ff__uf_aol_db.csv" ymax(dB20(getData("loopGain" ?result "stb")))))
    errset(mtxDump("/home/mseminario2/vestarv/implementations/asic/castalia/analog/data/raw/ab_unity_stb__ff__uf_gm.csv" (- value(dB20(getData("loopGain" ?result "stb")) cross(phase(getData("loopGain" ?result "stb")) 0 1 "falling")))))
    errset(mtxDump("/home/mseminario2/vestarv/implementations/asic/castalia/analog/data/raw/ab_unity_stb__ff__uf_pm.csv" value(phase(getData("loopGain" ?result "stb")) cross(dB20(getData("loopGain" ?result "stb")) 0 1 "falling"))))
    errset(mtxDump("/home/mseminario2/vestarv/implementations/asic/castalia/analog/data/raw/ab_unity_stb__ff__uf_ugf.csv" cross(dB20(getData("loopGain" ?result "stb")) 0 1 "falling")))
  )
)

;; ---- corner 3 (fs) / test ab_amp_op
when(isDir("/home/mseminario2/chips/castalia/ic/.simulation/castalia/tb_anatop_tia_amp_ab/maestro/results/maestro/Interactive.14/3/TypOpenLoopTB/psf")
  openResults("/home/mseminario2/chips/castalia/ic/.simulation/castalia/tb_anatop_tia_amp_ab/maestro/results/maestro/Interactive.14/3/TypOpenLoopTB/psf")
  when(member('dcOp results())
    selectResult('dcOp)
    mtxP = outfile("/home/mseminario2/vestarv/implementations/asic/castalia/analog/data/raw/ab_amp_op__fs.meta" "w")
    fprintf(mtxP "sweep %%L\n" car(errset(sweepNames())))
    close(mtxP)
    errset(mtxDump("/home/mseminario2/vestarv/implementations/asic/castalia/analog/data/raw/ab_amp_op__fs__p_opamp.csv" getData("OPAMP:pwr" ?result "dcOp")))
  )
)

;; ---- corner 3 (fs) / test ab_drive_dc
when(isDir("/home/mseminario2/chips/castalia/ic/.simulation/castalia/tb_anatop_tia_amp_ab/maestro/results/maestro/Interactive.14/3/DriveTB/psf")
  openResults("/home/mseminario2/chips/castalia/ic/.simulation/castalia/tb_anatop_tia_amp_ab/maestro/results/maestro/Interactive.14/3/DriveTB/psf")
  when(member('dc results())
    selectResult('dc)
    mtxP = outfile("/home/mseminario2/vestarv/implementations/asic/castalia/analog/data/raw/ab_drive_dc__fs.meta" "w")
    fprintf(mtxP "sweep %%L\n" car(errset(sweepNames())))
    close(mtxP)
    errset(mtxDump("/home/mseminario2/vestarv/implementations/asic/castalia/analog/data/raw/ab_drive_dc__fs__i_sink_50m.csv" abs(cross(abs((VS("/V_OutOL") - VAR("V_CM"))) 0.05 1 "falling"))))
    errset(mtxDump("/home/mseminario2/vestarv/implementations/asic/castalia/analog/data/raw/ab_drive_dc__fs__i_src_50m.csv" cross(abs((VS("/V_OutOL") - VAR("V_CM"))) 0.05 1 "rising")))
  )
)

;; ---- corner 3 (fs) / test ab_tiafb_ac
when(isDir("/home/mseminario2/chips/castalia/ic/.simulation/castalia/tb_anatop_tia_amp_ab/maestro/results/maestro/Interactive.14/3/TiaFbTB/psf")
  openResults("/home/mseminario2/chips/castalia/ic/.simulation/castalia/tb_anatop_tia_amp_ab/maestro/results/maestro/Interactive.14/3/TiaFbTB/psf")
  when(member('ac results())
    selectResult('ac)
    mtxP = outfile("/home/mseminario2/vestarv/implementations/asic/castalia/analog/data/raw/ab_tiafb_ac__fs.meta" "w")
    fprintf(mtxP "sweep %%L\n" car(errset(sweepNames())))
    close(mtxP)
    errset(mtxDump("/home/mseminario2/vestarv/implementations/asic/castalia/analog/data/raw/ab_tiafb_ac__fs__f3db.csv" bandwidth(VF("/V_OUT") 3 "low")))
    errset(mtxDump("/home/mseminario2/vestarv/implementations/asic/castalia/analog/data/raw/ab_tiafb_ac__fs__peaking_db.csv" dB20((ymax(mag(VF("/V_OUT"))) / value(mag(VF("/V_OUT")) 1)))))
    errset(mtxDump("/home/mseminario2/vestarv/implementations/asic/castalia/analog/data/raw/ab_tiafb_ac__fs__zt.csv" mag(VF("/V_OUT"))))
    errset(mtxDump("/home/mseminario2/vestarv/implementations/asic/castalia/analog/data/raw/ab_tiafb_ac__fs__zt0.csv" value(mag(VF("/V_OUT")) 1)))
    errset(mtxDump("/home/mseminario2/vestarv/implementations/asic/castalia/analog/data/raw/ab_tiafb_ac__fs__zt_err.csv" ((value(mag(VF("/V_OUT")) 1) - VAR("rf")) / VAR("rf"))))
  )
)

;; ---- corner 3 (fs) / test ab_tiafb_dc
when(isDir("/home/mseminario2/chips/castalia/ic/.simulation/castalia/tb_anatop_tia_amp_ab/maestro/results/maestro/Interactive.14/3/TiaFbTB/psf")
  openResults("/home/mseminario2/chips/castalia/ic/.simulation/castalia/tb_anatop_tia_amp_ab/maestro/results/maestro/Interactive.14/3/TiaFbTB/psf")
  when(member('dc results())
    selectResult('dc)
    mtxP = outfile("/home/mseminario2/vestarv/implementations/asic/castalia/analog/data/raw/ab_tiafb_dc__fs.meta" "w")
    fprintf(mtxP "sweep %%L\n" car(errset(sweepNames())))
    close(mtxP)
    errset(mtxDump("/home/mseminario2/vestarv/implementations/asic/castalia/analog/data/raw/ab_tiafb_dc__fs__gain_err.csv" (((value(VS("/V_OUT") min(0.9 ((8e-06 * VAR("rf")) / VAR("vfs")))) - value(VS("/V_OUT") (- min(0.9 ((8e-06 * VAR("rf")) / VAR("vfs")))))) / (2 * min(0.9 ((8e-06 * VAR("rf")) / VAR("vfs")))) / VAR("vfs")) - 1)))
    errset(mtxDump("/home/mseminario2/vestarv/implementations/asic/castalia/analog/data/raw/ab_tiafb_dc__fs__inl_lsb.csv" (ymax(abs(clip((VS("/V_OUT") - (value(VS("/V_OUT") (- min(0.9 ((8e-06 * VAR("rf")) / VAR("vfs"))))) + (((value(VS("/V_OUT") min(0.9 ((8e-06 * VAR("rf")) / VAR("vfs")))) - value(VS("/V_OUT") (- min(0.9 ((8e-06 * VAR("rf")) / VAR("vfs")))))) / (2 * min(0.9 ((8e-06 * VAR("rf")) / VAR("vfs"))))) * (xval(VS("/V_OUT")) + min(0.9 ((8e-06 * VAR("rf")) / VAR("vfs"))))))) (- min(0.9 ((8e-06 * VAR("rf")) / VAR("vfs")))) min(0.9 ((8e-06 * VAR("rf")) / VAR("vfs")))))) / 0.002441)))
    errset(mtxDump("/home/mseminario2/vestarv/implementations/asic/castalia/analog/data/raw/ab_tiafb_dc__fs__voff.csv" (value(VS("/V_OUT") 0) - VAR("V_CM"))))
  )
)

;; ---- corner 3 (fs) / test ab_tiafb_noise
when(isDir("/home/mseminario2/chips/castalia/ic/.simulation/castalia/tb_anatop_tia_amp_ab/maestro/results/maestro/Interactive.14/3/TiaFbTB/psf")
  openResults("/home/mseminario2/chips/castalia/ic/.simulation/castalia/tb_anatop_tia_amp_ab/maestro/results/maestro/Interactive.14/3/TiaFbTB/psf")
  when(member('noise results())
    selectResult('noise)
    mtxP = outfile("/home/mseminario2/vestarv/implementations/asic/castalia/analog/data/raw/ab_tiafb_noise__fs.meta" "w")
    fprintf(mtxP "sweep %%L\n" car(errset(sweepNames())))
    close(mtxP)
    errset(mtxDump("/home/mseminario2/vestarv/implementations/asic/castalia/analog/data/raw/ab_tiafb_noise__fs__in_rms_10.csv" (rmsNoise(0.1 10) / VAR("rf"))))
    errset(mtxDump("/home/mseminario2/vestarv/implementations/asic/castalia/analog/data/raw/ab_tiafb_noise__fs__in_rms_100.csv" (rmsNoise(0.1 100) / VAR("rf"))))
    errset(mtxDump("/home/mseminario2/vestarv/implementations/asic/castalia/analog/data/raw/ab_tiafb_noise__fs__in_rms_1k.csv" (rmsNoise(0.1 1000.0) / VAR("rf"))))
    errset(mtxDump("/home/mseminario2/vestarv/implementations/asic/castalia/analog/data/raw/ab_tiafb_noise__fs__vn_out.csv" rmsNoise(0.1 1000.0)))
  )
)

;; ---- corner 3 (fs) / test ab_tiafb_stb
when(isDir("/home/mseminario2/chips/castalia/ic/.simulation/castalia/tb_anatop_tia_amp_ab/maestro/results/maestro/Interactive.14/3/TiaFbTB/psf")
  openResults("/home/mseminario2/chips/castalia/ic/.simulation/castalia/tb_anatop_tia_amp_ab/maestro/results/maestro/Interactive.14/3/TiaFbTB/psf")
  when(member('stb results())
    selectResult('stb)
    mtxP = outfile("/home/mseminario2/vestarv/implementations/asic/castalia/analog/data/raw/ab_tiafb_stb__fs.meta" "w")
    fprintf(mtxP "sweep %%L\n" car(errset(sweepNames())))
    close(mtxP)
    errset(mtxDump("/home/mseminario2/vestarv/implementations/asic/castalia/analog/data/raw/ab_tiafb_stb__fs__lg_db.csv" dB20(getData("loopGain" ?result "stb"))))
    errset(mtxDump("/home/mseminario2/vestarv/implementations/asic/castalia/analog/data/raw/ab_tiafb_stb__fs__stb_aol_db.csv" ymax(dB20(getData("loopGain" ?result "stb")))))
    errset(mtxDump("/home/mseminario2/vestarv/implementations/asic/castalia/analog/data/raw/ab_tiafb_stb__fs__stb_fx.csv" cross(dB20(getData("loopGain" ?result "stb")) 0 1 "falling")))
    errset(mtxDump("/home/mseminario2/vestarv/implementations/asic/castalia/analog/data/raw/ab_tiafb_stb__fs__stb_gm.csv" (- value(dB20(getData("loopGain" ?result "stb")) cross(clip(phase(getData("loopGain" ?result "stb")) cross(dB20(getData("loopGain" ?result "stb")) 0 1 "falling") 100000000) 0 1 "falling")))))
    errset(mtxDump("/home/mseminario2/vestarv/implementations/asic/castalia/analog/data/raw/ab_tiafb_stb__fs__stb_pm.csv" value(phase(getData("loopGain" ?result "stb")) cross(dB20(getData("loopGain" ?result "stb")) 0 1 "falling"))))
  )
)

;; ---- corner 3 (fs) / test ab_unity_stb
when(isDir("/home/mseminario2/chips/castalia/ic/.simulation/castalia/tb_anatop_tia_amp_ab/maestro/results/maestro/Interactive.14/3/UnityFeedbackTB/psf")
  openResults("/home/mseminario2/chips/castalia/ic/.simulation/castalia/tb_anatop_tia_amp_ab/maestro/results/maestro/Interactive.14/3/UnityFeedbackTB/psf")
  when(member('stb results())
    selectResult('stb)
    mtxP = outfile("/home/mseminario2/vestarv/implementations/asic/castalia/analog/data/raw/ab_unity_stb__fs.meta" "w")
    fprintf(mtxP "sweep %%L\n" car(errset(sweepNames())))
    close(mtxP)
    errset(mtxDump("/home/mseminario2/vestarv/implementations/asic/castalia/analog/data/raw/ab_unity_stb__fs__uf_aol_db.csv" ymax(dB20(getData("loopGain" ?result "stb")))))
    errset(mtxDump("/home/mseminario2/vestarv/implementations/asic/castalia/analog/data/raw/ab_unity_stb__fs__uf_gm.csv" (- value(dB20(getData("loopGain" ?result "stb")) cross(phase(getData("loopGain" ?result "stb")) 0 1 "falling")))))
    errset(mtxDump("/home/mseminario2/vestarv/implementations/asic/castalia/analog/data/raw/ab_unity_stb__fs__uf_pm.csv" value(phase(getData("loopGain" ?result "stb")) cross(dB20(getData("loopGain" ?result "stb")) 0 1 "falling"))))
    errset(mtxDump("/home/mseminario2/vestarv/implementations/asic/castalia/analog/data/raw/ab_unity_stb__fs__uf_ugf.csv" cross(dB20(getData("loopGain" ?result "stb")) 0 1 "falling")))
  )
)

;; ---- corner 4 (sf) / test ab_amp_op
when(isDir("/home/mseminario2/chips/castalia/ic/.simulation/castalia/tb_anatop_tia_amp_ab/maestro/results/maestro/Interactive.14/4/TypOpenLoopTB/psf")
  openResults("/home/mseminario2/chips/castalia/ic/.simulation/castalia/tb_anatop_tia_amp_ab/maestro/results/maestro/Interactive.14/4/TypOpenLoopTB/psf")
  when(member('dcOp results())
    selectResult('dcOp)
    mtxP = outfile("/home/mseminario2/vestarv/implementations/asic/castalia/analog/data/raw/ab_amp_op__sf.meta" "w")
    fprintf(mtxP "sweep %%L\n" car(errset(sweepNames())))
    close(mtxP)
    errset(mtxDump("/home/mseminario2/vestarv/implementations/asic/castalia/analog/data/raw/ab_amp_op__sf__p_opamp.csv" getData("OPAMP:pwr" ?result "dcOp")))
  )
)

;; ---- corner 4 (sf) / test ab_drive_dc
when(isDir("/home/mseminario2/chips/castalia/ic/.simulation/castalia/tb_anatop_tia_amp_ab/maestro/results/maestro/Interactive.14/4/DriveTB/psf")
  openResults("/home/mseminario2/chips/castalia/ic/.simulation/castalia/tb_anatop_tia_amp_ab/maestro/results/maestro/Interactive.14/4/DriveTB/psf")
  when(member('dc results())
    selectResult('dc)
    mtxP = outfile("/home/mseminario2/vestarv/implementations/asic/castalia/analog/data/raw/ab_drive_dc__sf.meta" "w")
    fprintf(mtxP "sweep %%L\n" car(errset(sweepNames())))
    close(mtxP)
    errset(mtxDump("/home/mseminario2/vestarv/implementations/asic/castalia/analog/data/raw/ab_drive_dc__sf__i_sink_50m.csv" abs(cross(abs((VS("/V_OutOL") - VAR("V_CM"))) 0.05 1 "falling"))))
    errset(mtxDump("/home/mseminario2/vestarv/implementations/asic/castalia/analog/data/raw/ab_drive_dc__sf__i_src_50m.csv" cross(abs((VS("/V_OutOL") - VAR("V_CM"))) 0.05 1 "rising")))
  )
)

;; ---- corner 4 (sf) / test ab_tiafb_ac
when(isDir("/home/mseminario2/chips/castalia/ic/.simulation/castalia/tb_anatop_tia_amp_ab/maestro/results/maestro/Interactive.14/4/TiaFbTB/psf")
  openResults("/home/mseminario2/chips/castalia/ic/.simulation/castalia/tb_anatop_tia_amp_ab/maestro/results/maestro/Interactive.14/4/TiaFbTB/psf")
  when(member('ac results())
    selectResult('ac)
    mtxP = outfile("/home/mseminario2/vestarv/implementations/asic/castalia/analog/data/raw/ab_tiafb_ac__sf.meta" "w")
    fprintf(mtxP "sweep %%L\n" car(errset(sweepNames())))
    close(mtxP)
    errset(mtxDump("/home/mseminario2/vestarv/implementations/asic/castalia/analog/data/raw/ab_tiafb_ac__sf__f3db.csv" bandwidth(VF("/V_OUT") 3 "low")))
    errset(mtxDump("/home/mseminario2/vestarv/implementations/asic/castalia/analog/data/raw/ab_tiafb_ac__sf__peaking_db.csv" dB20((ymax(mag(VF("/V_OUT"))) / value(mag(VF("/V_OUT")) 1)))))
    errset(mtxDump("/home/mseminario2/vestarv/implementations/asic/castalia/analog/data/raw/ab_tiafb_ac__sf__zt.csv" mag(VF("/V_OUT"))))
    errset(mtxDump("/home/mseminario2/vestarv/implementations/asic/castalia/analog/data/raw/ab_tiafb_ac__sf__zt0.csv" value(mag(VF("/V_OUT")) 1)))
    errset(mtxDump("/home/mseminario2/vestarv/implementations/asic/castalia/analog/data/raw/ab_tiafb_ac__sf__zt_err.csv" ((value(mag(VF("/V_OUT")) 1) - VAR("rf")) / VAR("rf"))))
  )
)

;; ---- corner 4 (sf) / test ab_tiafb_dc
when(isDir("/home/mseminario2/chips/castalia/ic/.simulation/castalia/tb_anatop_tia_amp_ab/maestro/results/maestro/Interactive.14/4/TiaFbTB/psf")
  openResults("/home/mseminario2/chips/castalia/ic/.simulation/castalia/tb_anatop_tia_amp_ab/maestro/results/maestro/Interactive.14/4/TiaFbTB/psf")
  when(member('dc results())
    selectResult('dc)
    mtxP = outfile("/home/mseminario2/vestarv/implementations/asic/castalia/analog/data/raw/ab_tiafb_dc__sf.meta" "w")
    fprintf(mtxP "sweep %%L\n" car(errset(sweepNames())))
    close(mtxP)
    errset(mtxDump("/home/mseminario2/vestarv/implementations/asic/castalia/analog/data/raw/ab_tiafb_dc__sf__gain_err.csv" (((value(VS("/V_OUT") min(0.9 ((8e-06 * VAR("rf")) / VAR("vfs")))) - value(VS("/V_OUT") (- min(0.9 ((8e-06 * VAR("rf")) / VAR("vfs")))))) / (2 * min(0.9 ((8e-06 * VAR("rf")) / VAR("vfs")))) / VAR("vfs")) - 1)))
    errset(mtxDump("/home/mseminario2/vestarv/implementations/asic/castalia/analog/data/raw/ab_tiafb_dc__sf__inl_lsb.csv" (ymax(abs(clip((VS("/V_OUT") - (value(VS("/V_OUT") (- min(0.9 ((8e-06 * VAR("rf")) / VAR("vfs"))))) + (((value(VS("/V_OUT") min(0.9 ((8e-06 * VAR("rf")) / VAR("vfs")))) - value(VS("/V_OUT") (- min(0.9 ((8e-06 * VAR("rf")) / VAR("vfs")))))) / (2 * min(0.9 ((8e-06 * VAR("rf")) / VAR("vfs"))))) * (xval(VS("/V_OUT")) + min(0.9 ((8e-06 * VAR("rf")) / VAR("vfs"))))))) (- min(0.9 ((8e-06 * VAR("rf")) / VAR("vfs")))) min(0.9 ((8e-06 * VAR("rf")) / VAR("vfs")))))) / 0.002441)))
    errset(mtxDump("/home/mseminario2/vestarv/implementations/asic/castalia/analog/data/raw/ab_tiafb_dc__sf__voff.csv" (value(VS("/V_OUT") 0) - VAR("V_CM"))))
  )
)

;; ---- corner 4 (sf) / test ab_tiafb_noise
when(isDir("/home/mseminario2/chips/castalia/ic/.simulation/castalia/tb_anatop_tia_amp_ab/maestro/results/maestro/Interactive.14/4/TiaFbTB/psf")
  openResults("/home/mseminario2/chips/castalia/ic/.simulation/castalia/tb_anatop_tia_amp_ab/maestro/results/maestro/Interactive.14/4/TiaFbTB/psf")
  when(member('noise results())
    selectResult('noise)
    mtxP = outfile("/home/mseminario2/vestarv/implementations/asic/castalia/analog/data/raw/ab_tiafb_noise__sf.meta" "w")
    fprintf(mtxP "sweep %%L\n" car(errset(sweepNames())))
    close(mtxP)
    errset(mtxDump("/home/mseminario2/vestarv/implementations/asic/castalia/analog/data/raw/ab_tiafb_noise__sf__in_rms_10.csv" (rmsNoise(0.1 10) / VAR("rf"))))
    errset(mtxDump("/home/mseminario2/vestarv/implementations/asic/castalia/analog/data/raw/ab_tiafb_noise__sf__in_rms_100.csv" (rmsNoise(0.1 100) / VAR("rf"))))
    errset(mtxDump("/home/mseminario2/vestarv/implementations/asic/castalia/analog/data/raw/ab_tiafb_noise__sf__in_rms_1k.csv" (rmsNoise(0.1 1000.0) / VAR("rf"))))
    errset(mtxDump("/home/mseminario2/vestarv/implementations/asic/castalia/analog/data/raw/ab_tiafb_noise__sf__vn_out.csv" rmsNoise(0.1 1000.0)))
  )
)

;; ---- corner 4 (sf) / test ab_tiafb_stb
when(isDir("/home/mseminario2/chips/castalia/ic/.simulation/castalia/tb_anatop_tia_amp_ab/maestro/results/maestro/Interactive.14/4/TiaFbTB/psf")
  openResults("/home/mseminario2/chips/castalia/ic/.simulation/castalia/tb_anatop_tia_amp_ab/maestro/results/maestro/Interactive.14/4/TiaFbTB/psf")
  when(member('stb results())
    selectResult('stb)
    mtxP = outfile("/home/mseminario2/vestarv/implementations/asic/castalia/analog/data/raw/ab_tiafb_stb__sf.meta" "w")
    fprintf(mtxP "sweep %%L\n" car(errset(sweepNames())))
    close(mtxP)
    errset(mtxDump("/home/mseminario2/vestarv/implementations/asic/castalia/analog/data/raw/ab_tiafb_stb__sf__lg_db.csv" dB20(getData("loopGain" ?result "stb"))))
    errset(mtxDump("/home/mseminario2/vestarv/implementations/asic/castalia/analog/data/raw/ab_tiafb_stb__sf__stb_aol_db.csv" ymax(dB20(getData("loopGain" ?result "stb")))))
    errset(mtxDump("/home/mseminario2/vestarv/implementations/asic/castalia/analog/data/raw/ab_tiafb_stb__sf__stb_fx.csv" cross(dB20(getData("loopGain" ?result "stb")) 0 1 "falling")))
    errset(mtxDump("/home/mseminario2/vestarv/implementations/asic/castalia/analog/data/raw/ab_tiafb_stb__sf__stb_gm.csv" (- value(dB20(getData("loopGain" ?result "stb")) cross(clip(phase(getData("loopGain" ?result "stb")) cross(dB20(getData("loopGain" ?result "stb")) 0 1 "falling") 100000000) 0 1 "falling")))))
    errset(mtxDump("/home/mseminario2/vestarv/implementations/asic/castalia/analog/data/raw/ab_tiafb_stb__sf__stb_pm.csv" value(phase(getData("loopGain" ?result "stb")) cross(dB20(getData("loopGain" ?result "stb")) 0 1 "falling"))))
  )
)

;; ---- corner 4 (sf) / test ab_unity_stb
when(isDir("/home/mseminario2/chips/castalia/ic/.simulation/castalia/tb_anatop_tia_amp_ab/maestro/results/maestro/Interactive.14/4/UnityFeedbackTB/psf")
  openResults("/home/mseminario2/chips/castalia/ic/.simulation/castalia/tb_anatop_tia_amp_ab/maestro/results/maestro/Interactive.14/4/UnityFeedbackTB/psf")
  when(member('stb results())
    selectResult('stb)
    mtxP = outfile("/home/mseminario2/vestarv/implementations/asic/castalia/analog/data/raw/ab_unity_stb__sf.meta" "w")
    fprintf(mtxP "sweep %%L\n" car(errset(sweepNames())))
    close(mtxP)
    errset(mtxDump("/home/mseminario2/vestarv/implementations/asic/castalia/analog/data/raw/ab_unity_stb__sf__uf_aol_db.csv" ymax(dB20(getData("loopGain" ?result "stb")))))
    errset(mtxDump("/home/mseminario2/vestarv/implementations/asic/castalia/analog/data/raw/ab_unity_stb__sf__uf_gm.csv" (- value(dB20(getData("loopGain" ?result "stb")) cross(phase(getData("loopGain" ?result "stb")) 0 1 "falling")))))
    errset(mtxDump("/home/mseminario2/vestarv/implementations/asic/castalia/analog/data/raw/ab_unity_stb__sf__uf_pm.csv" value(phase(getData("loopGain" ?result "stb")) cross(dB20(getData("loopGain" ?result "stb")) 0 1 "falling"))))
    errset(mtxDump("/home/mseminario2/vestarv/implementations/asic/castalia/analog/data/raw/ab_unity_stb__sf__uf_ugf.csv" cross(dB20(getData("loopGain" ?result "stb")) 0 1 "falling")))
  )
)

;; ---- corner 5 (ss) / test ab_amp_op
when(isDir("/home/mseminario2/chips/castalia/ic/.simulation/castalia/tb_anatop_tia_amp_ab/maestro/results/maestro/Interactive.14/5/TypOpenLoopTB/psf")
  openResults("/home/mseminario2/chips/castalia/ic/.simulation/castalia/tb_anatop_tia_amp_ab/maestro/results/maestro/Interactive.14/5/TypOpenLoopTB/psf")
  when(member('dcOp results())
    selectResult('dcOp)
    mtxP = outfile("/home/mseminario2/vestarv/implementations/asic/castalia/analog/data/raw/ab_amp_op__ss.meta" "w")
    fprintf(mtxP "sweep %%L\n" car(errset(sweepNames())))
    close(mtxP)
    errset(mtxDump("/home/mseminario2/vestarv/implementations/asic/castalia/analog/data/raw/ab_amp_op__ss__p_opamp.csv" getData("OPAMP:pwr" ?result "dcOp")))
  )
)

;; ---- corner 5 (ss) / test ab_drive_dc
when(isDir("/home/mseminario2/chips/castalia/ic/.simulation/castalia/tb_anatop_tia_amp_ab/maestro/results/maestro/Interactive.14/5/DriveTB/psf")
  openResults("/home/mseminario2/chips/castalia/ic/.simulation/castalia/tb_anatop_tia_amp_ab/maestro/results/maestro/Interactive.14/5/DriveTB/psf")
  when(member('dc results())
    selectResult('dc)
    mtxP = outfile("/home/mseminario2/vestarv/implementations/asic/castalia/analog/data/raw/ab_drive_dc__ss.meta" "w")
    fprintf(mtxP "sweep %%L\n" car(errset(sweepNames())))
    close(mtxP)
    errset(mtxDump("/home/mseminario2/vestarv/implementations/asic/castalia/analog/data/raw/ab_drive_dc__ss__i_sink_50m.csv" abs(cross(abs((VS("/V_OutOL") - VAR("V_CM"))) 0.05 1 "falling"))))
    errset(mtxDump("/home/mseminario2/vestarv/implementations/asic/castalia/analog/data/raw/ab_drive_dc__ss__i_src_50m.csv" cross(abs((VS("/V_OutOL") - VAR("V_CM"))) 0.05 1 "rising")))
  )
)

;; ---- corner 5 (ss) / test ab_tiafb_ac
when(isDir("/home/mseminario2/chips/castalia/ic/.simulation/castalia/tb_anatop_tia_amp_ab/maestro/results/maestro/Interactive.14/5/TiaFbTB/psf")
  openResults("/home/mseminario2/chips/castalia/ic/.simulation/castalia/tb_anatop_tia_amp_ab/maestro/results/maestro/Interactive.14/5/TiaFbTB/psf")
  when(member('ac results())
    selectResult('ac)
    mtxP = outfile("/home/mseminario2/vestarv/implementations/asic/castalia/analog/data/raw/ab_tiafb_ac__ss.meta" "w")
    fprintf(mtxP "sweep %%L\n" car(errset(sweepNames())))
    close(mtxP)
    errset(mtxDump("/home/mseminario2/vestarv/implementations/asic/castalia/analog/data/raw/ab_tiafb_ac__ss__f3db.csv" bandwidth(VF("/V_OUT") 3 "low")))
    errset(mtxDump("/home/mseminario2/vestarv/implementations/asic/castalia/analog/data/raw/ab_tiafb_ac__ss__peaking_db.csv" dB20((ymax(mag(VF("/V_OUT"))) / value(mag(VF("/V_OUT")) 1)))))
    errset(mtxDump("/home/mseminario2/vestarv/implementations/asic/castalia/analog/data/raw/ab_tiafb_ac__ss__zt.csv" mag(VF("/V_OUT"))))
    errset(mtxDump("/home/mseminario2/vestarv/implementations/asic/castalia/analog/data/raw/ab_tiafb_ac__ss__zt0.csv" value(mag(VF("/V_OUT")) 1)))
    errset(mtxDump("/home/mseminario2/vestarv/implementations/asic/castalia/analog/data/raw/ab_tiafb_ac__ss__zt_err.csv" ((value(mag(VF("/V_OUT")) 1) - VAR("rf")) / VAR("rf"))))
  )
)

;; ---- corner 5 (ss) / test ab_tiafb_dc
when(isDir("/home/mseminario2/chips/castalia/ic/.simulation/castalia/tb_anatop_tia_amp_ab/maestro/results/maestro/Interactive.14/5/TiaFbTB/psf")
  openResults("/home/mseminario2/chips/castalia/ic/.simulation/castalia/tb_anatop_tia_amp_ab/maestro/results/maestro/Interactive.14/5/TiaFbTB/psf")
  when(member('dc results())
    selectResult('dc)
    mtxP = outfile("/home/mseminario2/vestarv/implementations/asic/castalia/analog/data/raw/ab_tiafb_dc__ss.meta" "w")
    fprintf(mtxP "sweep %%L\n" car(errset(sweepNames())))
    close(mtxP)
    errset(mtxDump("/home/mseminario2/vestarv/implementations/asic/castalia/analog/data/raw/ab_tiafb_dc__ss__gain_err.csv" (((value(VS("/V_OUT") min(0.9 ((8e-06 * VAR("rf")) / VAR("vfs")))) - value(VS("/V_OUT") (- min(0.9 ((8e-06 * VAR("rf")) / VAR("vfs")))))) / (2 * min(0.9 ((8e-06 * VAR("rf")) / VAR("vfs")))) / VAR("vfs")) - 1)))
    errset(mtxDump("/home/mseminario2/vestarv/implementations/asic/castalia/analog/data/raw/ab_tiafb_dc__ss__inl_lsb.csv" (ymax(abs(clip((VS("/V_OUT") - (value(VS("/V_OUT") (- min(0.9 ((8e-06 * VAR("rf")) / VAR("vfs"))))) + (((value(VS("/V_OUT") min(0.9 ((8e-06 * VAR("rf")) / VAR("vfs")))) - value(VS("/V_OUT") (- min(0.9 ((8e-06 * VAR("rf")) / VAR("vfs")))))) / (2 * min(0.9 ((8e-06 * VAR("rf")) / VAR("vfs"))))) * (xval(VS("/V_OUT")) + min(0.9 ((8e-06 * VAR("rf")) / VAR("vfs"))))))) (- min(0.9 ((8e-06 * VAR("rf")) / VAR("vfs")))) min(0.9 ((8e-06 * VAR("rf")) / VAR("vfs")))))) / 0.002441)))
    errset(mtxDump("/home/mseminario2/vestarv/implementations/asic/castalia/analog/data/raw/ab_tiafb_dc__ss__voff.csv" (value(VS("/V_OUT") 0) - VAR("V_CM"))))
  )
)

;; ---- corner 5 (ss) / test ab_tiafb_noise
when(isDir("/home/mseminario2/chips/castalia/ic/.simulation/castalia/tb_anatop_tia_amp_ab/maestro/results/maestro/Interactive.14/5/TiaFbTB/psf")
  openResults("/home/mseminario2/chips/castalia/ic/.simulation/castalia/tb_anatop_tia_amp_ab/maestro/results/maestro/Interactive.14/5/TiaFbTB/psf")
  when(member('noise results())
    selectResult('noise)
    mtxP = outfile("/home/mseminario2/vestarv/implementations/asic/castalia/analog/data/raw/ab_tiafb_noise__ss.meta" "w")
    fprintf(mtxP "sweep %%L\n" car(errset(sweepNames())))
    close(mtxP)
    errset(mtxDump("/home/mseminario2/vestarv/implementations/asic/castalia/analog/data/raw/ab_tiafb_noise__ss__in_rms_10.csv" (rmsNoise(0.1 10) / VAR("rf"))))
    errset(mtxDump("/home/mseminario2/vestarv/implementations/asic/castalia/analog/data/raw/ab_tiafb_noise__ss__in_rms_100.csv" (rmsNoise(0.1 100) / VAR("rf"))))
    errset(mtxDump("/home/mseminario2/vestarv/implementations/asic/castalia/analog/data/raw/ab_tiafb_noise__ss__in_rms_1k.csv" (rmsNoise(0.1 1000.0) / VAR("rf"))))
    errset(mtxDump("/home/mseminario2/vestarv/implementations/asic/castalia/analog/data/raw/ab_tiafb_noise__ss__vn_out.csv" rmsNoise(0.1 1000.0)))
  )
)

;; ---- corner 5 (ss) / test ab_tiafb_stb
when(isDir("/home/mseminario2/chips/castalia/ic/.simulation/castalia/tb_anatop_tia_amp_ab/maestro/results/maestro/Interactive.14/5/TiaFbTB/psf")
  openResults("/home/mseminario2/chips/castalia/ic/.simulation/castalia/tb_anatop_tia_amp_ab/maestro/results/maestro/Interactive.14/5/TiaFbTB/psf")
  when(member('stb results())
    selectResult('stb)
    mtxP = outfile("/home/mseminario2/vestarv/implementations/asic/castalia/analog/data/raw/ab_tiafb_stb__ss.meta" "w")
    fprintf(mtxP "sweep %%L\n" car(errset(sweepNames())))
    close(mtxP)
    errset(mtxDump("/home/mseminario2/vestarv/implementations/asic/castalia/analog/data/raw/ab_tiafb_stb__ss__lg_db.csv" dB20(getData("loopGain" ?result "stb"))))
    errset(mtxDump("/home/mseminario2/vestarv/implementations/asic/castalia/analog/data/raw/ab_tiafb_stb__ss__stb_aol_db.csv" ymax(dB20(getData("loopGain" ?result "stb")))))
    errset(mtxDump("/home/mseminario2/vestarv/implementations/asic/castalia/analog/data/raw/ab_tiafb_stb__ss__stb_fx.csv" cross(dB20(getData("loopGain" ?result "stb")) 0 1 "falling")))
    errset(mtxDump("/home/mseminario2/vestarv/implementations/asic/castalia/analog/data/raw/ab_tiafb_stb__ss__stb_gm.csv" (- value(dB20(getData("loopGain" ?result "stb")) cross(clip(phase(getData("loopGain" ?result "stb")) cross(dB20(getData("loopGain" ?result "stb")) 0 1 "falling") 100000000) 0 1 "falling")))))
    errset(mtxDump("/home/mseminario2/vestarv/implementations/asic/castalia/analog/data/raw/ab_tiafb_stb__ss__stb_pm.csv" value(phase(getData("loopGain" ?result "stb")) cross(dB20(getData("loopGain" ?result "stb")) 0 1 "falling"))))
  )
)

;; ---- corner 5 (ss) / test ab_unity_stb
when(isDir("/home/mseminario2/chips/castalia/ic/.simulation/castalia/tb_anatop_tia_amp_ab/maestro/results/maestro/Interactive.14/5/UnityFeedbackTB/psf")
  openResults("/home/mseminario2/chips/castalia/ic/.simulation/castalia/tb_anatop_tia_amp_ab/maestro/results/maestro/Interactive.14/5/UnityFeedbackTB/psf")
  when(member('stb results())
    selectResult('stb)
    mtxP = outfile("/home/mseminario2/vestarv/implementations/asic/castalia/analog/data/raw/ab_unity_stb__ss.meta" "w")
    fprintf(mtxP "sweep %%L\n" car(errset(sweepNames())))
    close(mtxP)
    errset(mtxDump("/home/mseminario2/vestarv/implementations/asic/castalia/analog/data/raw/ab_unity_stb__ss__uf_aol_db.csv" ymax(dB20(getData("loopGain" ?result "stb")))))
    errset(mtxDump("/home/mseminario2/vestarv/implementations/asic/castalia/analog/data/raw/ab_unity_stb__ss__uf_gm.csv" (- value(dB20(getData("loopGain" ?result "stb")) cross(phase(getData("loopGain" ?result "stb")) 0 1 "falling")))))
    errset(mtxDump("/home/mseminario2/vestarv/implementations/asic/castalia/analog/data/raw/ab_unity_stb__ss__uf_pm.csv" value(phase(getData("loopGain" ?result "stb")) cross(dB20(getData("loopGain" ?result "stb")) 0 1 "falling"))))
    errset(mtxDump("/home/mseminario2/vestarv/implementations/asic/castalia/analog/data/raw/ab_unity_stb__ss__uf_ugf.csv" cross(dB20(getData("loopGain" ?result "stb")) 0 1 "falling")))
  )
)

printf("MTX_EXTRACT_DONE\n")
exit(0)
