;; generated by maestro2tex -- do not edit
procedure(mtxDump(fname wv)
  let((xs ys n p)
    p = outfile(fname "w")
    cond(
      (null(wv) fprintf(p "#nil\n"))
      (drIsWaveform(wv)
        xs = drGetWaveformXVec(wv)
        ys = drGetWaveformYVec(wv)
        n = drVectorLength(xs)
        for(i 0 n-1
          fprintf(p "%.10g %.10g\n" drGetElem(xs i) drGetElem(ys i)))
      )
      (t fprintf(p "#scalar %.10g\n" float(wv)))
    )
    close(p)
    t))

;; ---- corner 1 (tt) / test cell_dc
when(isDir("/home/mseminario2/chips/castalia/simarchive/anatop_tb_controlamp/cm_2026-07-27/Interactive.158/1/CellDriveTB/psf")
  openResults("/home/mseminario2/chips/castalia/simarchive/anatop_tb_controlamp/cm_2026-07-27/Interactive.158/1/CellDriveTB/psf")
  when(member('dc results())
    selectResult('dc)
    mtxP = outfile("/home/mseminario2/vestarv/implementations/asic/castalia/analog/data/raw/cell_dc__tt.meta" "w")
    fprintf(mtxP "sweep %%L\n" car(errset(sweepNames())))
    close(mtxP)
    errset(mtxDump("/home/mseminario2/vestarv/implementations/asic/castalia/analog/data/raw/cell_dc__tt__ce_hi.csv" ymax(VS("/CE"))))
    errset(mtxDump("/home/mseminario2/vestarv/implementations/asic/castalia/analog/data/raw/cell_dc__tt__ce_lo.csv" ymin(VS("/CE"))))
    errset(mtxDump("/home/mseminario2/vestarv/implementations/asic/castalia/analog/data/raw/cell_dc__tt__ce_w.csv" VS("/CE")))
    errset(mtxDump("/home/mseminario2/vestarv/implementations/asic/castalia/analog/data/raw/cell_dc__tt__head_hi.csv" (VAR("VDD25") - ymax(VS("/CE")))))
    errset(mtxDump("/home/mseminario2/vestarv/implementations/asic/castalia/analog/data/raw/cell_dc__tt__head_lo.csv" ymin(VS("/CE"))))
    errset(mtxDump("/home/mseminario2/vestarv/implementations/asic/castalia/analog/data/raw/cell_dc__tt__i_sink_max.csv" abs(ymin(IS("/SRC_WE/PLUS")))))
    errset(mtxDump("/home/mseminario2/vestarv/implementations/asic/castalia/analog/data/raw/cell_dc__tt__i_src_max.csv" ymax(IS("/SRC_WE/PLUS"))))
    errset(mtxDump("/home/mseminario2/vestarv/implementations/asic/castalia/analog/data/raw/cell_dc__tt__i_tot.csv" abs(IDC("/POWER/SRC_VDD25/PLUS"))))
    errset(mtxDump("/home/mseminario2/vestarv/implementations/asic/castalia/analog/data/raw/cell_dc__tt__icell.csv" IS("/SRC_WE/PLUS")))
    errset(mtxDump("/home/mseminario2/vestarv/implementations/asic/castalia/analog/data/raw/cell_dc__tt__re_err.csv" (VS("/RE") - xval(VS("/RE")))))
    errset(mtxDump("/home/mseminario2/vestarv/implementations/asic/castalia/analog/data/raw/cell_dc__tt__re_err_0.csv" value((VS("/RE") - xval(VS("/RE"))) VAR("V_CM"))))
    errset(mtxDump("/home/mseminario2/vestarv/implementations/asic/castalia/analog/data/raw/cell_dc__tt__re_err_p10.csv" value((VS("/RE") - xval(VS("/RE"))) cross(IS("/SRC_WE/PLUS") 1e-05 1 "rising"))))
  )
)

;; ---- corner 1 (tt) / test cell_stb
when(isDir("/home/mseminario2/chips/castalia/simarchive/anatop_tb_controlamp/cm_2026-07-27/Interactive.158/1/CellDriveTB/psf")
  openResults("/home/mseminario2/chips/castalia/simarchive/anatop_tb_controlamp/cm_2026-07-27/Interactive.158/1/CellDriveTB/psf")
  when(member('stb results())
    selectResult('stb)
    mtxP = outfile("/home/mseminario2/vestarv/implementations/asic/castalia/analog/data/raw/cell_stb__tt.meta" "w")
    fprintf(mtxP "sweep %%L\n" car(errset(sweepNames())))
    close(mtxP)
    errset(mtxDump("/home/mseminario2/vestarv/implementations/asic/castalia/analog/data/raw/cell_stb__tt__aol_db.csv" ymax(dB20(getData("loopGain" ?result "stb")))))
    errset(mtxDump("/home/mseminario2/vestarv/implementations/asic/castalia/analog/data/raw/cell_stb__tt__lg_db.csv" dB20(getData("loopGain" ?result "stb"))))
    errset(mtxDump("/home/mseminario2/vestarv/implementations/asic/castalia/analog/data/raw/cell_stb__tt__pm.csv" value(phase(getData("loopGain" ?result "stb")) cross(dB20(getData("loopGain" ?result "stb")) 0 1 "falling"))))
    errset(mtxDump("/home/mseminario2/vestarv/implementations/asic/castalia/analog/data/raw/cell_stb__tt__ugf.csv" cross(dB20(getData("loopGain" ?result "stb")) 0 1 "falling")))
  )
)

;; ---- corner 2 (ff) / test cell_dc
when(isDir("/home/mseminario2/chips/castalia/simarchive/anatop_tb_controlamp/cm_2026-07-27/Interactive.158/2/CellDriveTB/psf")
  openResults("/home/mseminario2/chips/castalia/simarchive/anatop_tb_controlamp/cm_2026-07-27/Interactive.158/2/CellDriveTB/psf")
  when(member('dc results())
    selectResult('dc)
    mtxP = outfile("/home/mseminario2/vestarv/implementations/asic/castalia/analog/data/raw/cell_dc__ff.meta" "w")
    fprintf(mtxP "sweep %%L\n" car(errset(sweepNames())))
    close(mtxP)
    errset(mtxDump("/home/mseminario2/vestarv/implementations/asic/castalia/analog/data/raw/cell_dc__ff__ce_hi.csv" ymax(VS("/CE"))))
    errset(mtxDump("/home/mseminario2/vestarv/implementations/asic/castalia/analog/data/raw/cell_dc__ff__ce_lo.csv" ymin(VS("/CE"))))
    errset(mtxDump("/home/mseminario2/vestarv/implementations/asic/castalia/analog/data/raw/cell_dc__ff__ce_w.csv" VS("/CE")))
    errset(mtxDump("/home/mseminario2/vestarv/implementations/asic/castalia/analog/data/raw/cell_dc__ff__head_hi.csv" (VAR("VDD25") - ymax(VS("/CE")))))
    errset(mtxDump("/home/mseminario2/vestarv/implementations/asic/castalia/analog/data/raw/cell_dc__ff__head_lo.csv" ymin(VS("/CE"))))
    errset(mtxDump("/home/mseminario2/vestarv/implementations/asic/castalia/analog/data/raw/cell_dc__ff__i_sink_max.csv" abs(ymin(IS("/SRC_WE/PLUS")))))
    errset(mtxDump("/home/mseminario2/vestarv/implementations/asic/castalia/analog/data/raw/cell_dc__ff__i_src_max.csv" ymax(IS("/SRC_WE/PLUS"))))
    errset(mtxDump("/home/mseminario2/vestarv/implementations/asic/castalia/analog/data/raw/cell_dc__ff__i_tot.csv" abs(IDC("/POWER/SRC_VDD25/PLUS"))))
    errset(mtxDump("/home/mseminario2/vestarv/implementations/asic/castalia/analog/data/raw/cell_dc__ff__icell.csv" IS("/SRC_WE/PLUS")))
    errset(mtxDump("/home/mseminario2/vestarv/implementations/asic/castalia/analog/data/raw/cell_dc__ff__re_err.csv" (VS("/RE") - xval(VS("/RE")))))
    errset(mtxDump("/home/mseminario2/vestarv/implementations/asic/castalia/analog/data/raw/cell_dc__ff__re_err_0.csv" value((VS("/RE") - xval(VS("/RE"))) VAR("V_CM"))))
    errset(mtxDump("/home/mseminario2/vestarv/implementations/asic/castalia/analog/data/raw/cell_dc__ff__re_err_p10.csv" value((VS("/RE") - xval(VS("/RE"))) cross(IS("/SRC_WE/PLUS") 1e-05 1 "rising"))))
  )
)

;; ---- corner 2 (ff) / test cell_stb
when(isDir("/home/mseminario2/chips/castalia/simarchive/anatop_tb_controlamp/cm_2026-07-27/Interactive.158/2/CellDriveTB/psf")
  openResults("/home/mseminario2/chips/castalia/simarchive/anatop_tb_controlamp/cm_2026-07-27/Interactive.158/2/CellDriveTB/psf")
  when(member('stb results())
    selectResult('stb)
    mtxP = outfile("/home/mseminario2/vestarv/implementations/asic/castalia/analog/data/raw/cell_stb__ff.meta" "w")
    fprintf(mtxP "sweep %%L\n" car(errset(sweepNames())))
    close(mtxP)
    errset(mtxDump("/home/mseminario2/vestarv/implementations/asic/castalia/analog/data/raw/cell_stb__ff__aol_db.csv" ymax(dB20(getData("loopGain" ?result "stb")))))
    errset(mtxDump("/home/mseminario2/vestarv/implementations/asic/castalia/analog/data/raw/cell_stb__ff__lg_db.csv" dB20(getData("loopGain" ?result "stb"))))
    errset(mtxDump("/home/mseminario2/vestarv/implementations/asic/castalia/analog/data/raw/cell_stb__ff__pm.csv" value(phase(getData("loopGain" ?result "stb")) cross(dB20(getData("loopGain" ?result "stb")) 0 1 "falling"))))
    errset(mtxDump("/home/mseminario2/vestarv/implementations/asic/castalia/analog/data/raw/cell_stb__ff__ugf.csv" cross(dB20(getData("loopGain" ?result "stb")) 0 1 "falling")))
  )
)

;; ---- corner 3 (fs) / test cell_dc
when(isDir("/home/mseminario2/chips/castalia/simarchive/anatop_tb_controlamp/cm_2026-07-27/Interactive.158/3/CellDriveTB/psf")
  openResults("/home/mseminario2/chips/castalia/simarchive/anatop_tb_controlamp/cm_2026-07-27/Interactive.158/3/CellDriveTB/psf")
  when(member('dc results())
    selectResult('dc)
    mtxP = outfile("/home/mseminario2/vestarv/implementations/asic/castalia/analog/data/raw/cell_dc__fs.meta" "w")
    fprintf(mtxP "sweep %%L\n" car(errset(sweepNames())))
    close(mtxP)
    errset(mtxDump("/home/mseminario2/vestarv/implementations/asic/castalia/analog/data/raw/cell_dc__fs__ce_hi.csv" ymax(VS("/CE"))))
    errset(mtxDump("/home/mseminario2/vestarv/implementations/asic/castalia/analog/data/raw/cell_dc__fs__ce_lo.csv" ymin(VS("/CE"))))
    errset(mtxDump("/home/mseminario2/vestarv/implementations/asic/castalia/analog/data/raw/cell_dc__fs__ce_w.csv" VS("/CE")))
    errset(mtxDump("/home/mseminario2/vestarv/implementations/asic/castalia/analog/data/raw/cell_dc__fs__head_hi.csv" (VAR("VDD25") - ymax(VS("/CE")))))
    errset(mtxDump("/home/mseminario2/vestarv/implementations/asic/castalia/analog/data/raw/cell_dc__fs__head_lo.csv" ymin(VS("/CE"))))
    errset(mtxDump("/home/mseminario2/vestarv/implementations/asic/castalia/analog/data/raw/cell_dc__fs__i_sink_max.csv" abs(ymin(IS("/SRC_WE/PLUS")))))
    errset(mtxDump("/home/mseminario2/vestarv/implementations/asic/castalia/analog/data/raw/cell_dc__fs__i_src_max.csv" ymax(IS("/SRC_WE/PLUS"))))
    errset(mtxDump("/home/mseminario2/vestarv/implementations/asic/castalia/analog/data/raw/cell_dc__fs__i_tot.csv" abs(IDC("/POWER/SRC_VDD25/PLUS"))))
    errset(mtxDump("/home/mseminario2/vestarv/implementations/asic/castalia/analog/data/raw/cell_dc__fs__icell.csv" IS("/SRC_WE/PLUS")))
    errset(mtxDump("/home/mseminario2/vestarv/implementations/asic/castalia/analog/data/raw/cell_dc__fs__re_err.csv" (VS("/RE") - xval(VS("/RE")))))
    errset(mtxDump("/home/mseminario2/vestarv/implementations/asic/castalia/analog/data/raw/cell_dc__fs__re_err_0.csv" value((VS("/RE") - xval(VS("/RE"))) VAR("V_CM"))))
    errset(mtxDump("/home/mseminario2/vestarv/implementations/asic/castalia/analog/data/raw/cell_dc__fs__re_err_p10.csv" value((VS("/RE") - xval(VS("/RE"))) cross(IS("/SRC_WE/PLUS") 1e-05 1 "rising"))))
  )
)

;; ---- corner 3 (fs) / test cell_stb
when(isDir("/home/mseminario2/chips/castalia/simarchive/anatop_tb_controlamp/cm_2026-07-27/Interactive.158/3/CellDriveTB/psf")
  openResults("/home/mseminario2/chips/castalia/simarchive/anatop_tb_controlamp/cm_2026-07-27/Interactive.158/3/CellDriveTB/psf")
  when(member('stb results())
    selectResult('stb)
    mtxP = outfile("/home/mseminario2/vestarv/implementations/asic/castalia/analog/data/raw/cell_stb__fs.meta" "w")
    fprintf(mtxP "sweep %%L\n" car(errset(sweepNames())))
    close(mtxP)
    errset(mtxDump("/home/mseminario2/vestarv/implementations/asic/castalia/analog/data/raw/cell_stb__fs__aol_db.csv" ymax(dB20(getData("loopGain" ?result "stb")))))
    errset(mtxDump("/home/mseminario2/vestarv/implementations/asic/castalia/analog/data/raw/cell_stb__fs__lg_db.csv" dB20(getData("loopGain" ?result "stb"))))
    errset(mtxDump("/home/mseminario2/vestarv/implementations/asic/castalia/analog/data/raw/cell_stb__fs__pm.csv" value(phase(getData("loopGain" ?result "stb")) cross(dB20(getData("loopGain" ?result "stb")) 0 1 "falling"))))
    errset(mtxDump("/home/mseminario2/vestarv/implementations/asic/castalia/analog/data/raw/cell_stb__fs__ugf.csv" cross(dB20(getData("loopGain" ?result "stb")) 0 1 "falling")))
  )
)

;; ---- corner 4 (sf) / test cell_dc
when(isDir("/home/mseminario2/chips/castalia/simarchive/anatop_tb_controlamp/cm_2026-07-27/Interactive.158/4/CellDriveTB/psf")
  openResults("/home/mseminario2/chips/castalia/simarchive/anatop_tb_controlamp/cm_2026-07-27/Interactive.158/4/CellDriveTB/psf")
  when(member('dc results())
    selectResult('dc)
    mtxP = outfile("/home/mseminario2/vestarv/implementations/asic/castalia/analog/data/raw/cell_dc__sf.meta" "w")
    fprintf(mtxP "sweep %%L\n" car(errset(sweepNames())))
    close(mtxP)
    errset(mtxDump("/home/mseminario2/vestarv/implementations/asic/castalia/analog/data/raw/cell_dc__sf__ce_hi.csv" ymax(VS("/CE"))))
    errset(mtxDump("/home/mseminario2/vestarv/implementations/asic/castalia/analog/data/raw/cell_dc__sf__ce_lo.csv" ymin(VS("/CE"))))
    errset(mtxDump("/home/mseminario2/vestarv/implementations/asic/castalia/analog/data/raw/cell_dc__sf__ce_w.csv" VS("/CE")))
    errset(mtxDump("/home/mseminario2/vestarv/implementations/asic/castalia/analog/data/raw/cell_dc__sf__head_hi.csv" (VAR("VDD25") - ymax(VS("/CE")))))
    errset(mtxDump("/home/mseminario2/vestarv/implementations/asic/castalia/analog/data/raw/cell_dc__sf__head_lo.csv" ymin(VS("/CE"))))
    errset(mtxDump("/home/mseminario2/vestarv/implementations/asic/castalia/analog/data/raw/cell_dc__sf__i_sink_max.csv" abs(ymin(IS("/SRC_WE/PLUS")))))
    errset(mtxDump("/home/mseminario2/vestarv/implementations/asic/castalia/analog/data/raw/cell_dc__sf__i_src_max.csv" ymax(IS("/SRC_WE/PLUS"))))
    errset(mtxDump("/home/mseminario2/vestarv/implementations/asic/castalia/analog/data/raw/cell_dc__sf__i_tot.csv" abs(IDC("/POWER/SRC_VDD25/PLUS"))))
    errset(mtxDump("/home/mseminario2/vestarv/implementations/asic/castalia/analog/data/raw/cell_dc__sf__icell.csv" IS("/SRC_WE/PLUS")))
    errset(mtxDump("/home/mseminario2/vestarv/implementations/asic/castalia/analog/data/raw/cell_dc__sf__re_err.csv" (VS("/RE") - xval(VS("/RE")))))
    errset(mtxDump("/home/mseminario2/vestarv/implementations/asic/castalia/analog/data/raw/cell_dc__sf__re_err_0.csv" value((VS("/RE") - xval(VS("/RE"))) VAR("V_CM"))))
    errset(mtxDump("/home/mseminario2/vestarv/implementations/asic/castalia/analog/data/raw/cell_dc__sf__re_err_p10.csv" value((VS("/RE") - xval(VS("/RE"))) cross(IS("/SRC_WE/PLUS") 1e-05 1 "rising"))))
  )
)

;; ---- corner 4 (sf) / test cell_stb
when(isDir("/home/mseminario2/chips/castalia/simarchive/anatop_tb_controlamp/cm_2026-07-27/Interactive.158/4/CellDriveTB/psf")
  openResults("/home/mseminario2/chips/castalia/simarchive/anatop_tb_controlamp/cm_2026-07-27/Interactive.158/4/CellDriveTB/psf")
  when(member('stb results())
    selectResult('stb)
    mtxP = outfile("/home/mseminario2/vestarv/implementations/asic/castalia/analog/data/raw/cell_stb__sf.meta" "w")
    fprintf(mtxP "sweep %%L\n" car(errset(sweepNames())))
    close(mtxP)
    errset(mtxDump("/home/mseminario2/vestarv/implementations/asic/castalia/analog/data/raw/cell_stb__sf__aol_db.csv" ymax(dB20(getData("loopGain" ?result "stb")))))
    errset(mtxDump("/home/mseminario2/vestarv/implementations/asic/castalia/analog/data/raw/cell_stb__sf__lg_db.csv" dB20(getData("loopGain" ?result "stb"))))
    errset(mtxDump("/home/mseminario2/vestarv/implementations/asic/castalia/analog/data/raw/cell_stb__sf__pm.csv" value(phase(getData("loopGain" ?result "stb")) cross(dB20(getData("loopGain" ?result "stb")) 0 1 "falling"))))
    errset(mtxDump("/home/mseminario2/vestarv/implementations/asic/castalia/analog/data/raw/cell_stb__sf__ugf.csv" cross(dB20(getData("loopGain" ?result "stb")) 0 1 "falling")))
  )
)

;; ---- corner 5 (ss) / test cell_dc
when(isDir("/home/mseminario2/chips/castalia/simarchive/anatop_tb_controlamp/cm_2026-07-27/Interactive.158/5/CellDriveTB/psf")
  openResults("/home/mseminario2/chips/castalia/simarchive/anatop_tb_controlamp/cm_2026-07-27/Interactive.158/5/CellDriveTB/psf")
  when(member('dc results())
    selectResult('dc)
    mtxP = outfile("/home/mseminario2/vestarv/implementations/asic/castalia/analog/data/raw/cell_dc__ss.meta" "w")
    fprintf(mtxP "sweep %%L\n" car(errset(sweepNames())))
    close(mtxP)
    errset(mtxDump("/home/mseminario2/vestarv/implementations/asic/castalia/analog/data/raw/cell_dc__ss__ce_hi.csv" ymax(VS("/CE"))))
    errset(mtxDump("/home/mseminario2/vestarv/implementations/asic/castalia/analog/data/raw/cell_dc__ss__ce_lo.csv" ymin(VS("/CE"))))
    errset(mtxDump("/home/mseminario2/vestarv/implementations/asic/castalia/analog/data/raw/cell_dc__ss__ce_w.csv" VS("/CE")))
    errset(mtxDump("/home/mseminario2/vestarv/implementations/asic/castalia/analog/data/raw/cell_dc__ss__head_hi.csv" (VAR("VDD25") - ymax(VS("/CE")))))
    errset(mtxDump("/home/mseminario2/vestarv/implementations/asic/castalia/analog/data/raw/cell_dc__ss__head_lo.csv" ymin(VS("/CE"))))
    errset(mtxDump("/home/mseminario2/vestarv/implementations/asic/castalia/analog/data/raw/cell_dc__ss__i_sink_max.csv" abs(ymin(IS("/SRC_WE/PLUS")))))
    errset(mtxDump("/home/mseminario2/vestarv/implementations/asic/castalia/analog/data/raw/cell_dc__ss__i_src_max.csv" ymax(IS("/SRC_WE/PLUS"))))
    errset(mtxDump("/home/mseminario2/vestarv/implementations/asic/castalia/analog/data/raw/cell_dc__ss__i_tot.csv" abs(IDC("/POWER/SRC_VDD25/PLUS"))))
    errset(mtxDump("/home/mseminario2/vestarv/implementations/asic/castalia/analog/data/raw/cell_dc__ss__icell.csv" IS("/SRC_WE/PLUS")))
    errset(mtxDump("/home/mseminario2/vestarv/implementations/asic/castalia/analog/data/raw/cell_dc__ss__re_err.csv" (VS("/RE") - xval(VS("/RE")))))
    errset(mtxDump("/home/mseminario2/vestarv/implementations/asic/castalia/analog/data/raw/cell_dc__ss__re_err_0.csv" value((VS("/RE") - xval(VS("/RE"))) VAR("V_CM"))))
    errset(mtxDump("/home/mseminario2/vestarv/implementations/asic/castalia/analog/data/raw/cell_dc__ss__re_err_p10.csv" value((VS("/RE") - xval(VS("/RE"))) cross(IS("/SRC_WE/PLUS") 1e-05 1 "rising"))))
  )
)

;; ---- corner 5 (ss) / test cell_stb
when(isDir("/home/mseminario2/chips/castalia/simarchive/anatop_tb_controlamp/cm_2026-07-27/Interactive.158/5/CellDriveTB/psf")
  openResults("/home/mseminario2/chips/castalia/simarchive/anatop_tb_controlamp/cm_2026-07-27/Interactive.158/5/CellDriveTB/psf")
  when(member('stb results())
    selectResult('stb)
    mtxP = outfile("/home/mseminario2/vestarv/implementations/asic/castalia/analog/data/raw/cell_stb__ss.meta" "w")
    fprintf(mtxP "sweep %%L\n" car(errset(sweepNames())))
    close(mtxP)
    errset(mtxDump("/home/mseminario2/vestarv/implementations/asic/castalia/analog/data/raw/cell_stb__ss__aol_db.csv" ymax(dB20(getData("loopGain" ?result "stb")))))
    errset(mtxDump("/home/mseminario2/vestarv/implementations/asic/castalia/analog/data/raw/cell_stb__ss__lg_db.csv" dB20(getData("loopGain" ?result "stb"))))
    errset(mtxDump("/home/mseminario2/vestarv/implementations/asic/castalia/analog/data/raw/cell_stb__ss__pm.csv" value(phase(getData("loopGain" ?result "stb")) cross(dB20(getData("loopGain" ?result "stb")) 0 1 "falling"))))
    errset(mtxDump("/home/mseminario2/vestarv/implementations/asic/castalia/analog/data/raw/cell_stb__ss__ugf.csv" cross(dB20(getData("loopGain" ?result "stb")) 0 1 "falling")))
  )
)

printf("MTX_EXTRACT_DONE\n")
exit(0)
