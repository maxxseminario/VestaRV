;; generated by maestro2tex -- do not edit
procedure(mtxDump(fname wv)
  let((xs ys n p)
    p = outfile(fname "w")
    cond(
      (null(wv) fprintf(p "#nil\n"))
      (drIsWaveform(wv)
        xs = drGetWaveformXVec(wv)
        ys = drGetWaveformYVec(wv)
        n = drVectorLength(xs)
        for(i 0 n-1
          fprintf(p "%.10g %.10g\n" drGetElem(xs i) drGetElem(ys i)))
      )
      (t fprintf(p "#scalar %.10g\n" float(wv)))
    )
    close(p)
    t))

;; ---- corner 1 (tt) / test ol_ac
when(isDir("/home/mseminario2/chips/castalia/ic/.simulation/castalia/anatop_tb_controlamp/maestro/results/maestro/Interactive.119/1/TypOpenLoopWBiasTB/psf")
  openResults("/home/mseminario2/chips/castalia/ic/.simulation/castalia/anatop_tb_controlamp/maestro/results/maestro/Interactive.119/1/TypOpenLoopWBiasTB/psf")
  when(member('ac results())
    selectResult('ac)
    mtxP = outfile("/home/mseminario2/vestarv/implementations/asic/castalia/analog/data/raw/ol_ac__tt.meta" "w")
    fprintf(mtxP "sweep %%L\n" car(errset(sweepNames())))
    close(mtxP)
    errset(mtxDump("/home/mseminario2/vestarv/implementations/asic/castalia/analog/data/raw/ol_ac__tt__a0_db.csv" dB20(value(v("/V_OutOL")/(v("/V_InP")-v("/V_InM")) 1e-3))))
    errset(mtxDump("/home/mseminario2/vestarv/implementations/asic/castalia/analog/data/raw/ol_ac__tt__a0_vv.csv" abs(value(v("/V_OutOL")/(v("/V_InP")-v("/V_InM")) 1e-3))))
    errset(mtxDump("/home/mseminario2/vestarv/implementations/asic/castalia/analog/data/raw/ol_ac__tt__av_db.csv" dB20(v("/V_OutOL")/(v("/V_InP")-v("/V_InM")))))
    errset(mtxDump("/home/mseminario2/vestarv/implementations/asic/castalia/analog/data/raw/ol_ac__tt__av_ph.csv" phaseDegUnwrapped(v("/V_OutOL")/(v("/V_InP")-v("/V_InM")))))
    errset(mtxDump("/home/mseminario2/vestarv/implementations/asic/castalia/analog/data/raw/ol_ac__tt__f3db.csv" bandwidth(v("/V_OutOL")/(v("/V_InP")-v("/V_InM")) 3 "low")))
    errset(mtxDump("/home/mseminario2/vestarv/implementations/asic/castalia/analog/data/raw/ol_ac__tt__gbw.csv" gainBwProd(v("/V_OutOL")/(v("/V_InP")-v("/V_InM")))))
    errset(mtxDump("/home/mseminario2/vestarv/implementations/asic/castalia/analog/data/raw/ol_ac__tt__ph_ugf.csv" value(phaseDegUnwrapped(v("/V_OutOL")/(v("/V_InP")-v("/V_InM"))) unityGainFreq(v("/V_OutOL")/(v("/V_InP")-v("/V_InM"))))))
    errset(mtxDump("/home/mseminario2/vestarv/implementations/asic/castalia/analog/data/raw/ol_ac__tt__ugf.csv" unityGainFreq(v("/V_OutOL")/(v("/V_InP")-v("/V_InM")))))
  )
)

;; ---- corner 1 (tt) / test ol_dc
when(isDir("/home/mseminario2/chips/castalia/ic/.simulation/castalia/anatop_tb_controlamp/maestro/results/maestro/Interactive.119/1/TypOpenLoopWBiasTB/psf")
  openResults("/home/mseminario2/chips/castalia/ic/.simulation/castalia/anatop_tb_controlamp/maestro/results/maestro/Interactive.119/1/TypOpenLoopWBiasTB/psf")
  when(member('dc results())
    selectResult('dc)
    mtxP = outfile("/home/mseminario2/vestarv/implementations/asic/castalia/analog/data/raw/ol_dc__tt.meta" "w")
    fprintf(mtxP "sweep %%L\n" car(errset(sweepNames())))
    close(mtxP)
    errset(mtxDump("/home/mseminario2/vestarv/implementations/asic/castalia/analog/data/raw/ol_dc__tt__idd.csv" abs(i("/POWER/SRC_VDD25/PLUS"))))
    errset(mtxDump("/home/mseminario2/vestarv/implementations/asic/castalia/analog/data/raw/ol_dc__tt__voh.csv" ymax(v("/V_OutOL"))))
    errset(mtxDump("/home/mseminario2/vestarv/implementations/asic/castalia/analog/data/raw/ol_dc__tt__vol.csv" ymin(v("/V_OutOL"))))
    errset(mtxDump("/home/mseminario2/vestarv/implementations/asic/castalia/analog/data/raw/ol_dc__tt__vos_ol.csv" cross(v("/V_OutOL") 1.25 1 "either")))
    errset(mtxDump("/home/mseminario2/vestarv/implementations/asic/castalia/analog/data/raw/ol_dc__tt__vout.csv" v("/V_OutOL")))
  )
)

;; ---- corner 1 (tt) / test slew
when(isDir("/home/mseminario2/chips/castalia/ic/.simulation/castalia/anatop_tb_controlamp/maestro/results/maestro/Interactive.119/1/SlewOpenLoopWBiasTB/psf")
  openResults("/home/mseminario2/chips/castalia/ic/.simulation/castalia/anatop_tb_controlamp/maestro/results/maestro/Interactive.119/1/SlewOpenLoopWBiasTB/psf")
  when(member('tran results())
    selectResult('tran)
    mtxP = outfile("/home/mseminario2/vestarv/implementations/asic/castalia/analog/data/raw/slew__tt.meta" "w")
    fprintf(mtxP "sweep %%L\n" car(errset(sweepNames())))
    close(mtxP)
    errset(mtxDump("/home/mseminario2/vestarv/implementations/asic/castalia/analog/data/raw/slew__tt__iload.csv" i("/C_L/PLUS")))
    errset(mtxDump("/home/mseminario2/vestarv/implementations/asic/castalia/analog/data/raw/slew__tt__ipk_snk.csv" abs(ymin(i("/C_L/PLUS")))))
    errset(mtxDump("/home/mseminario2/vestarv/implementations/asic/castalia/analog/data/raw/slew__tt__ipk_src.csv" ymax(i("/C_L/PLUS"))))
    errset(mtxDump("/home/mseminario2/vestarv/implementations/asic/castalia/analog/data/raw/slew__tt__isnk.csv" abs(average(clip(i("/C_L/PLUS") cross(v("/V_OutOL") 2.25 1 "falling") cross(v("/V_OutOL") 0.25 1 "falling"))))))
    errset(mtxDump("/home/mseminario2/vestarv/implementations/asic/castalia/analog/data/raw/slew__tt__isrc.csv" average(clip(i("/C_L/PLUS") cross(v("/V_OutOL") 0.25 1 "rising") cross(v("/V_OutOL") 2.25 1 "rising")))))
    errset(mtxDump("/home/mseminario2/vestarv/implementations/asic/castalia/analog/data/raw/slew__tt__sr_dn.csv" 2.0/(cross(v("/V_OutOL") 0.25 1 "falling")-cross(v("/V_OutOL") 2.25 1 "falling"))))
    errset(mtxDump("/home/mseminario2/vestarv/implementations/asic/castalia/analog/data/raw/slew__tt__sr_up.csv" 2.0/(cross(v("/V_OutOL") 2.25 1 "rising")-cross(v("/V_OutOL") 0.25 1 "rising"))))
    errset(mtxDump("/home/mseminario2/vestarv/implementations/asic/castalia/analog/data/raw/slew__tt__vin.csv" v("/V_InP")))
    errset(mtxDump("/home/mseminario2/vestarv/implementations/asic/castalia/analog/data/raw/slew__tt__vout.csv" v("/V_OutOL")))
  )
)

;; ---- corner 1 (tt) / test uf_dc
when(isDir("/home/mseminario2/chips/castalia/ic/.simulation/castalia/anatop_tb_controlamp/maestro/results/maestro/Interactive.119/1/UnityFeedbackWBiasTB/psf")
  openResults("/home/mseminario2/chips/castalia/ic/.simulation/castalia/anatop_tb_controlamp/maestro/results/maestro/Interactive.119/1/UnityFeedbackWBiasTB/psf")
  when(member('dc results())
    selectResult('dc)
    mtxP = outfile("/home/mseminario2/vestarv/implementations/asic/castalia/analog/data/raw/uf_dc__tt.meta" "w")
    fprintf(mtxP "sweep %%L\n" car(errset(sweepNames())))
    close(mtxP)
    errset(mtxDump("/home/mseminario2/vestarv/implementations/asic/castalia/analog/data/raw/uf_dc__tt__idd.csv" abs(i("/POWER/SRC_VDD25/PLUS"))))
    errset(mtxDump("/home/mseminario2/vestarv/implementations/asic/castalia/analog/data/raw/uf_dc__tt__verr.csv" (v("/V_OutOL")-v("/V_InP"))))
    errset(mtxDump("/home/mseminario2/vestarv/implementations/asic/castalia/analog/data/raw/uf_dc__tt__vin_hi.csv" cross(abs(v("/V_OutOL")-v("/V_InP")) 1e-3 1 "rising")))
    errset(mtxDump("/home/mseminario2/vestarv/implementations/asic/castalia/analog/data/raw/uf_dc__tt__vin_lo.csv" cross(abs(v("/V_OutOL")-v("/V_InP")) 1e-3 1 "falling")))
    errset(mtxDump("/home/mseminario2/vestarv/implementations/asic/castalia/analog/data/raw/uf_dc__tt__vos.csv" value(v("/V_OutOL")-v("/V_InP") 1.25)))
    errset(mtxDump("/home/mseminario2/vestarv/implementations/asic/castalia/analog/data/raw/uf_dc__tt__vout.csv" v("/V_OutOL")))
  )
)

;; ---- corner 1 (tt) / test uf_margin
when(isDir("/home/mseminario2/chips/castalia/ic/.simulation/castalia/anatop_tb_controlamp/maestro/results/maestro/Interactive.119/1/UnityFeedbackWBiasTB/psf")
  openResults("/home/mseminario2/chips/castalia/ic/.simulation/castalia/anatop_tb_controlamp/maestro/results/maestro/Interactive.119/1/UnityFeedbackWBiasTB/psf")
  when(member('stb_margin results())
    selectResult('stb_margin)
    mtxP = outfile("/home/mseminario2/vestarv/implementations/asic/castalia/analog/data/raw/uf_margin__tt.meta" "w")
    fprintf(mtxP "sweep %%L\n" car(errset(sweepNames())))
    close(mtxP)
    errset(mtxDump("/home/mseminario2/vestarv/implementations/asic/castalia/analog/data/raw/uf_margin__tt__gm.csv" getData("gainMargin" ?result "stb_margin")))
    errset(mtxDump("/home/mseminario2/vestarv/implementations/asic/castalia/analog/data/raw/uf_margin__tt__gmf.csv" getData("gainMarginFreq" ?result "stb_margin")))
    errset(mtxDump("/home/mseminario2/vestarv/implementations/asic/castalia/analog/data/raw/uf_margin__tt__lg0_db.csv" dB20(value(getData("loopGain" ?result "stb") 1.0))))
    errset(mtxDump("/home/mseminario2/vestarv/implementations/asic/castalia/analog/data/raw/uf_margin__tt__lg_ugf.csv" unityGainFreq(getData("loopGain" ?result "stb"))))
    errset(mtxDump("/home/mseminario2/vestarv/implementations/asic/castalia/analog/data/raw/uf_margin__tt__pm.csv" getData("phaseMargin" ?result "stb_margin")))
    errset(mtxDump("/home/mseminario2/vestarv/implementations/asic/castalia/analog/data/raw/uf_margin__tt__pmf.csv" getData("phaseMarginFreq" ?result "stb_margin")))
  )
)

;; ---- corner 1 (tt) / test uf_noise
when(isDir("/home/mseminario2/chips/castalia/ic/.simulation/castalia/anatop_tb_controlamp/maestro/results/maestro/Interactive.119/1/UnityFeedbackWBiasTB/psf")
  openResults("/home/mseminario2/chips/castalia/ic/.simulation/castalia/anatop_tb_controlamp/maestro/results/maestro/Interactive.119/1/UnityFeedbackWBiasTB/psf")
  when(member('noise results())
    selectResult('noise)
    mtxP = outfile("/home/mseminario2/vestarv/implementations/asic/castalia/analog/data/raw/uf_noise__tt.meta" "w")
    fprintf(mtxP "sweep %%L\n" car(errset(sweepNames())))
    close(mtxP)
    errset(mtxDump("/home/mseminario2/vestarv/implementations/asic/castalia/analog/data/raw/uf_noise__tt__fcorner.csv" cross(getData("out") sqrt(2)*value(getData("out") 3e5) 1 "either")))
    errset(mtxDump("/home/mseminario2/vestarv/implementations/asic/castalia/analog/data/raw/uf_noise__tt__nfloor.csv" value(getData("out") 3e5)))
    errset(mtxDump("/home/mseminario2/vestarv/implementations/asic/castalia/analog/data/raw/uf_noise__tt__nint_10k.csv" sqrt(integ(getData("out")**2 0.1 1e4))))
    errset(mtxDump("/home/mseminario2/vestarv/implementations/asic/castalia/analog/data/raw/uf_noise__tt__nint_1M.csv" sqrt(integ(getData("out")**2 0.1 1e6))))
    errset(mtxDump("/home/mseminario2/vestarv/implementations/asic/castalia/analog/data/raw/uf_noise__tt__nout.csv" getData("out")))
    errset(mtxDump("/home/mseminario2/vestarv/implementations/asic/castalia/analog/data/raw/uf_noise__tt__nout_1.csv" value(getData("out") 1.0)))
    errset(mtxDump("/home/mseminario2/vestarv/implementations/asic/castalia/analog/data/raw/uf_noise__tt__nout_1k.csv" value(getData("out") 1e3)))
  )
)

;; ---- corner 1 (tt) / test uf_op
when(isDir("/home/mseminario2/chips/castalia/ic/.simulation/castalia/anatop_tb_controlamp/maestro/results/maestro/Interactive.119/1/UnityFeedbackWBiasTB/psf")
  openResults("/home/mseminario2/chips/castalia/ic/.simulation/castalia/anatop_tb_controlamp/maestro/results/maestro/Interactive.119/1/UnityFeedbackWBiasTB/psf")
  when(member('dcOp results())
    selectResult('dcOp)
    mtxP = outfile("/home/mseminario2/vestarv/implementations/asic/castalia/analog/data/raw/uf_op__tt.meta" "w")
    fprintf(mtxP "sweep %%L\n" car(errset(sweepNames())))
    close(mtxP)
    errset(mtxDump("/home/mseminario2/vestarv/implementations/asic/castalia/analog/data/raw/uf_op__tt__iamp.csv" abs(i("/OPAMP/vdd!"))))
    errset(mtxDump("/home/mseminario2/vestarv/implementations/asic/castalia/analog/data/raw/uf_op__tt__itot.csv" abs(i("/POWER/SRC_VDD25/PLUS"))))
    errset(mtxDump("/home/mseminario2/vestarv/implementations/asic/castalia/analog/data/raw/uf_op__tt__vbnc.csv" v("/V_BNC")))
    errset(mtxDump("/home/mseminario2/vestarv/implementations/asic/castalia/analog/data/raw/uf_op__tt__vbnm.csv" v("/V_BNM")))
    errset(mtxDump("/home/mseminario2/vestarv/implementations/asic/castalia/analog/data/raw/uf_op__tt__vbpc.csv" v("/V_BPC")))
    errset(mtxDump("/home/mseminario2/vestarv/implementations/asic/castalia/analog/data/raw/uf_op__tt__vbpm.csv" v("/V_BPM")))
    errset(mtxDump("/home/mseminario2/vestarv/implementations/asic/castalia/analog/data/raw/uf_op__tt__vout_op.csv" v("/V_OutOL")))
  )
)

printf("MTX_EXTRACT_DONE\n")
exit(0)
