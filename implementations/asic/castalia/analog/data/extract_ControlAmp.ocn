;; generated by maestro2tex -- do not edit
procedure(mtxDump(fname wv)
  let((xs ys n p)
    p = outfile(fname "w")
    cond(
      (null(wv) fprintf(p "#nil\n"))
      (drIsWaveform(wv)
        xs = drGetWaveformXVec(wv)
        ys = drGetWaveformYVec(wv)
        n = drVectorLength(xs)
        for(i 0 n-1
          fprintf(p "%.10g %.10g\n" drGetElem(xs i) drGetElem(ys i)))
      )
      (t fprintf(p "#scalar %.10g\n" float(wv)))
    )
    close(p)
    t))

;; ---- corner 136 (tt) / test ol_ac
when(isDir("/home/mseminario2/chips/castalia/simarchive/anatop_tb_controlamp/Interactive.137/136/TypOpenLoopWBiasTB/psf")
  openResults("/home/mseminario2/chips/castalia/simarchive/anatop_tb_controlamp/Interactive.137/136/TypOpenLoopWBiasTB/psf")
  when(member('ac results())
    selectResult('ac)
    mtxP = outfile("/home/mseminario2/vestarv/implementations/asic/castalia/analog/data/raw/ol_ac__tt.meta" "w")
    fprintf(mtxP "sweep %%L\n" car(errset(sweepNames())))
    close(mtxP)
    errset(mtxDump("/home/mseminario2/vestarv/implementations/asic/castalia/analog/data/raw/ol_ac__tt__a0_db.csv" dB20(value(v("/V_OutOL")/(v("/V_InP")-v("/V_InM")) 1e-3))))
    errset(mtxDump("/home/mseminario2/vestarv/implementations/asic/castalia/analog/data/raw/ol_ac__tt__a0_vv.csv" abs(value(v("/V_OutOL")/(v("/V_InP")-v("/V_InM")) 1e-3))))
    errset(mtxDump("/home/mseminario2/vestarv/implementations/asic/castalia/analog/data/raw/ol_ac__tt__av_db.csv" dB20(v("/V_OutOL")/(v("/V_InP")-v("/V_InM")))))
    errset(mtxDump("/home/mseminario2/vestarv/implementations/asic/castalia/analog/data/raw/ol_ac__tt__av_ph.csv" phaseDegUnwrapped(v("/V_OutOL")/(v("/V_InP")-v("/V_InM")))))
    errset(mtxDump("/home/mseminario2/vestarv/implementations/asic/castalia/analog/data/raw/ol_ac__tt__f3db.csv" bandwidth(v("/V_OutOL")/(v("/V_InP")-v("/V_InM")) 3 "low")))
    errset(mtxDump("/home/mseminario2/vestarv/implementations/asic/castalia/analog/data/raw/ol_ac__tt__gbw.csv" gainBwProd(v("/V_OutOL")/(v("/V_InP")-v("/V_InM")))))
    errset(mtxDump("/home/mseminario2/vestarv/implementations/asic/castalia/analog/data/raw/ol_ac__tt__ph_ugf.csv" value(phaseDegUnwrapped(v("/V_OutOL")/(v("/V_InP")-v("/V_InM"))) unityGainFreq(v("/V_OutOL")/(v("/V_InP")-v("/V_InM"))))))
    errset(mtxDump("/home/mseminario2/vestarv/implementations/asic/castalia/analog/data/raw/ol_ac__tt__ugf.csv" unityGainFreq(v("/V_OutOL")/(v("/V_InP")-v("/V_InM")))))
  )
)

;; ---- corner 136 (tt) / test ol_dc
when(isDir("/home/mseminario2/chips/castalia/simarchive/anatop_tb_controlamp/Interactive.137/136/TypOpenLoopWBiasTB/psf")
  openResults("/home/mseminario2/chips/castalia/simarchive/anatop_tb_controlamp/Interactive.137/136/TypOpenLoopWBiasTB/psf")
  when(member('dc results())
    selectResult('dc)
    mtxP = outfile("/home/mseminario2/vestarv/implementations/asic/castalia/analog/data/raw/ol_dc__tt.meta" "w")
    fprintf(mtxP "sweep %%L\n" car(errset(sweepNames())))
    close(mtxP)
    errset(mtxDump("/home/mseminario2/vestarv/implementations/asic/castalia/analog/data/raw/ol_dc__tt__idd.csv" abs(i("/POWER/SRC_VDD25/PLUS"))))
    errset(mtxDump("/home/mseminario2/vestarv/implementations/asic/castalia/analog/data/raw/ol_dc__tt__voh.csv" ymax(v("/V_OutOL"))))
    errset(mtxDump("/home/mseminario2/vestarv/implementations/asic/castalia/analog/data/raw/ol_dc__tt__vol.csv" ymin(v("/V_OutOL"))))
    errset(mtxDump("/home/mseminario2/vestarv/implementations/asic/castalia/analog/data/raw/ol_dc__tt__vos_ol.csv" cross(v("/V_OutOL") 1.25 1 "either")))
    errset(mtxDump("/home/mseminario2/vestarv/implementations/asic/castalia/analog/data/raw/ol_dc__tt__vout.csv" v("/V_OutOL")))
  )
)

;; ---- corner 137 (ff) / test ol_ac
when(isDir("/home/mseminario2/chips/castalia/simarchive/anatop_tb_controlamp/Interactive.137/137/TypOpenLoopWBiasTB/psf")
  openResults("/home/mseminario2/chips/castalia/simarchive/anatop_tb_controlamp/Interactive.137/137/TypOpenLoopWBiasTB/psf")
  when(member('ac results())
    selectResult('ac)
    mtxP = outfile("/home/mseminario2/vestarv/implementations/asic/castalia/analog/data/raw/ol_ac__ff.meta" "w")
    fprintf(mtxP "sweep %%L\n" car(errset(sweepNames())))
    close(mtxP)
    errset(mtxDump("/home/mseminario2/vestarv/implementations/asic/castalia/analog/data/raw/ol_ac__ff__a0_db.csv" dB20(value(v("/V_OutOL")/(v("/V_InP")-v("/V_InM")) 1e-3))))
    errset(mtxDump("/home/mseminario2/vestarv/implementations/asic/castalia/analog/data/raw/ol_ac__ff__a0_vv.csv" abs(value(v("/V_OutOL")/(v("/V_InP")-v("/V_InM")) 1e-3))))
    errset(mtxDump("/home/mseminario2/vestarv/implementations/asic/castalia/analog/data/raw/ol_ac__ff__av_db.csv" dB20(v("/V_OutOL")/(v("/V_InP")-v("/V_InM")))))
    errset(mtxDump("/home/mseminario2/vestarv/implementations/asic/castalia/analog/data/raw/ol_ac__ff__av_ph.csv" phaseDegUnwrapped(v("/V_OutOL")/(v("/V_InP")-v("/V_InM")))))
    errset(mtxDump("/home/mseminario2/vestarv/implementations/asic/castalia/analog/data/raw/ol_ac__ff__f3db.csv" bandwidth(v("/V_OutOL")/(v("/V_InP")-v("/V_InM")) 3 "low")))
    errset(mtxDump("/home/mseminario2/vestarv/implementations/asic/castalia/analog/data/raw/ol_ac__ff__gbw.csv" gainBwProd(v("/V_OutOL")/(v("/V_InP")-v("/V_InM")))))
    errset(mtxDump("/home/mseminario2/vestarv/implementations/asic/castalia/analog/data/raw/ol_ac__ff__ph_ugf.csv" value(phaseDegUnwrapped(v("/V_OutOL")/(v("/V_InP")-v("/V_InM"))) unityGainFreq(v("/V_OutOL")/(v("/V_InP")-v("/V_InM"))))))
    errset(mtxDump("/home/mseminario2/vestarv/implementations/asic/castalia/analog/data/raw/ol_ac__ff__ugf.csv" unityGainFreq(v("/V_OutOL")/(v("/V_InP")-v("/V_InM")))))
  )
)

;; ---- corner 137 (ff) / test ol_dc
when(isDir("/home/mseminario2/chips/castalia/simarchive/anatop_tb_controlamp/Interactive.137/137/TypOpenLoopWBiasTB/psf")
  openResults("/home/mseminario2/chips/castalia/simarchive/anatop_tb_controlamp/Interactive.137/137/TypOpenLoopWBiasTB/psf")
  when(member('dc results())
    selectResult('dc)
    mtxP = outfile("/home/mseminario2/vestarv/implementations/asic/castalia/analog/data/raw/ol_dc__ff.meta" "w")
    fprintf(mtxP "sweep %%L\n" car(errset(sweepNames())))
    close(mtxP)
    errset(mtxDump("/home/mseminario2/vestarv/implementations/asic/castalia/analog/data/raw/ol_dc__ff__idd.csv" abs(i("/POWER/SRC_VDD25/PLUS"))))
    errset(mtxDump("/home/mseminario2/vestarv/implementations/asic/castalia/analog/data/raw/ol_dc__ff__voh.csv" ymax(v("/V_OutOL"))))
    errset(mtxDump("/home/mseminario2/vestarv/implementations/asic/castalia/analog/data/raw/ol_dc__ff__vol.csv" ymin(v("/V_OutOL"))))
    errset(mtxDump("/home/mseminario2/vestarv/implementations/asic/castalia/analog/data/raw/ol_dc__ff__vos_ol.csv" cross(v("/V_OutOL") 1.25 1 "either")))
    errset(mtxDump("/home/mseminario2/vestarv/implementations/asic/castalia/analog/data/raw/ol_dc__ff__vout.csv" v("/V_OutOL")))
  )
)

;; ---- corner 138 (fs) / test ol_ac
when(isDir("/home/mseminario2/chips/castalia/simarchive/anatop_tb_controlamp/Interactive.137/138/TypOpenLoopWBiasTB/psf")
  openResults("/home/mseminario2/chips/castalia/simarchive/anatop_tb_controlamp/Interactive.137/138/TypOpenLoopWBiasTB/psf")
  when(member('ac results())
    selectResult('ac)
    mtxP = outfile("/home/mseminario2/vestarv/implementations/asic/castalia/analog/data/raw/ol_ac__fs.meta" "w")
    fprintf(mtxP "sweep %%L\n" car(errset(sweepNames())))
    close(mtxP)
    errset(mtxDump("/home/mseminario2/vestarv/implementations/asic/castalia/analog/data/raw/ol_ac__fs__a0_db.csv" dB20(value(v("/V_OutOL")/(v("/V_InP")-v("/V_InM")) 1e-3))))
    errset(mtxDump("/home/mseminario2/vestarv/implementations/asic/castalia/analog/data/raw/ol_ac__fs__a0_vv.csv" abs(value(v("/V_OutOL")/(v("/V_InP")-v("/V_InM")) 1e-3))))
    errset(mtxDump("/home/mseminario2/vestarv/implementations/asic/castalia/analog/data/raw/ol_ac__fs__av_db.csv" dB20(v("/V_OutOL")/(v("/V_InP")-v("/V_InM")))))
    errset(mtxDump("/home/mseminario2/vestarv/implementations/asic/castalia/analog/data/raw/ol_ac__fs__av_ph.csv" phaseDegUnwrapped(v("/V_OutOL")/(v("/V_InP")-v("/V_InM")))))
    errset(mtxDump("/home/mseminario2/vestarv/implementations/asic/castalia/analog/data/raw/ol_ac__fs__f3db.csv" bandwidth(v("/V_OutOL")/(v("/V_InP")-v("/V_InM")) 3 "low")))
    errset(mtxDump("/home/mseminario2/vestarv/implementations/asic/castalia/analog/data/raw/ol_ac__fs__gbw.csv" gainBwProd(v("/V_OutOL")/(v("/V_InP")-v("/V_InM")))))
    errset(mtxDump("/home/mseminario2/vestarv/implementations/asic/castalia/analog/data/raw/ol_ac__fs__ph_ugf.csv" value(phaseDegUnwrapped(v("/V_OutOL")/(v("/V_InP")-v("/V_InM"))) unityGainFreq(v("/V_OutOL")/(v("/V_InP")-v("/V_InM"))))))
    errset(mtxDump("/home/mseminario2/vestarv/implementations/asic/castalia/analog/data/raw/ol_ac__fs__ugf.csv" unityGainFreq(v("/V_OutOL")/(v("/V_InP")-v("/V_InM")))))
  )
)

;; ---- corner 138 (fs) / test ol_dc
when(isDir("/home/mseminario2/chips/castalia/simarchive/anatop_tb_controlamp/Interactive.137/138/TypOpenLoopWBiasTB/psf")
  openResults("/home/mseminario2/chips/castalia/simarchive/anatop_tb_controlamp/Interactive.137/138/TypOpenLoopWBiasTB/psf")
  when(member('dc results())
    selectResult('dc)
    mtxP = outfile("/home/mseminario2/vestarv/implementations/asic/castalia/analog/data/raw/ol_dc__fs.meta" "w")
    fprintf(mtxP "sweep %%L\n" car(errset(sweepNames())))
    close(mtxP)
    errset(mtxDump("/home/mseminario2/vestarv/implementations/asic/castalia/analog/data/raw/ol_dc__fs__idd.csv" abs(i("/POWER/SRC_VDD25/PLUS"))))
    errset(mtxDump("/home/mseminario2/vestarv/implementations/asic/castalia/analog/data/raw/ol_dc__fs__voh.csv" ymax(v("/V_OutOL"))))
    errset(mtxDump("/home/mseminario2/vestarv/implementations/asic/castalia/analog/data/raw/ol_dc__fs__vol.csv" ymin(v("/V_OutOL"))))
    errset(mtxDump("/home/mseminario2/vestarv/implementations/asic/castalia/analog/data/raw/ol_dc__fs__vos_ol.csv" cross(v("/V_OutOL") 1.25 1 "either")))
    errset(mtxDump("/home/mseminario2/vestarv/implementations/asic/castalia/analog/data/raw/ol_dc__fs__vout.csv" v("/V_OutOL")))
  )
)

;; ---- corner 139 (sf) / test ol_ac
when(isDir("/home/mseminario2/chips/castalia/simarchive/anatop_tb_controlamp/Interactive.137/139/TypOpenLoopWBiasTB/psf")
  openResults("/home/mseminario2/chips/castalia/simarchive/anatop_tb_controlamp/Interactive.137/139/TypOpenLoopWBiasTB/psf")
  when(member('ac results())
    selectResult('ac)
    mtxP = outfile("/home/mseminario2/vestarv/implementations/asic/castalia/analog/data/raw/ol_ac__sf.meta" "w")
    fprintf(mtxP "sweep %%L\n" car(errset(sweepNames())))
    close(mtxP)
    errset(mtxDump("/home/mseminario2/vestarv/implementations/asic/castalia/analog/data/raw/ol_ac__sf__a0_db.csv" dB20(value(v("/V_OutOL")/(v("/V_InP")-v("/V_InM")) 1e-3))))
    errset(mtxDump("/home/mseminario2/vestarv/implementations/asic/castalia/analog/data/raw/ol_ac__sf__a0_vv.csv" abs(value(v("/V_OutOL")/(v("/V_InP")-v("/V_InM")) 1e-3))))
    errset(mtxDump("/home/mseminario2/vestarv/implementations/asic/castalia/analog/data/raw/ol_ac__sf__av_db.csv" dB20(v("/V_OutOL")/(v("/V_InP")-v("/V_InM")))))
    errset(mtxDump("/home/mseminario2/vestarv/implementations/asic/castalia/analog/data/raw/ol_ac__sf__av_ph.csv" phaseDegUnwrapped(v("/V_OutOL")/(v("/V_InP")-v("/V_InM")))))
    errset(mtxDump("/home/mseminario2/vestarv/implementations/asic/castalia/analog/data/raw/ol_ac__sf__f3db.csv" bandwidth(v("/V_OutOL")/(v("/V_InP")-v("/V_InM")) 3 "low")))
    errset(mtxDump("/home/mseminario2/vestarv/implementations/asic/castalia/analog/data/raw/ol_ac__sf__gbw.csv" gainBwProd(v("/V_OutOL")/(v("/V_InP")-v("/V_InM")))))
    errset(mtxDump("/home/mseminario2/vestarv/implementations/asic/castalia/analog/data/raw/ol_ac__sf__ph_ugf.csv" value(phaseDegUnwrapped(v("/V_OutOL")/(v("/V_InP")-v("/V_InM"))) unityGainFreq(v("/V_OutOL")/(v("/V_InP")-v("/V_InM"))))))
    errset(mtxDump("/home/mseminario2/vestarv/implementations/asic/castalia/analog/data/raw/ol_ac__sf__ugf.csv" unityGainFreq(v("/V_OutOL")/(v("/V_InP")-v("/V_InM")))))
  )
)

;; ---- corner 139 (sf) / test ol_dc
when(isDir("/home/mseminario2/chips/castalia/simarchive/anatop_tb_controlamp/Interactive.137/139/TypOpenLoopWBiasTB/psf")
  openResults("/home/mseminario2/chips/castalia/simarchive/anatop_tb_controlamp/Interactive.137/139/TypOpenLoopWBiasTB/psf")
  when(member('dc results())
    selectResult('dc)
    mtxP = outfile("/home/mseminario2/vestarv/implementations/asic/castalia/analog/data/raw/ol_dc__sf.meta" "w")
    fprintf(mtxP "sweep %%L\n" car(errset(sweepNames())))
    close(mtxP)
    errset(mtxDump("/home/mseminario2/vestarv/implementations/asic/castalia/analog/data/raw/ol_dc__sf__idd.csv" abs(i("/POWER/SRC_VDD25/PLUS"))))
    errset(mtxDump("/home/mseminario2/vestarv/implementations/asic/castalia/analog/data/raw/ol_dc__sf__voh.csv" ymax(v("/V_OutOL"))))
    errset(mtxDump("/home/mseminario2/vestarv/implementations/asic/castalia/analog/data/raw/ol_dc__sf__vol.csv" ymin(v("/V_OutOL"))))
    errset(mtxDump("/home/mseminario2/vestarv/implementations/asic/castalia/analog/data/raw/ol_dc__sf__vos_ol.csv" cross(v("/V_OutOL") 1.25 1 "either")))
    errset(mtxDump("/home/mseminario2/vestarv/implementations/asic/castalia/analog/data/raw/ol_dc__sf__vout.csv" v("/V_OutOL")))
  )
)

;; ---- corner 140 (ss) / test ol_ac
when(isDir("/home/mseminario2/chips/castalia/simarchive/anatop_tb_controlamp/Interactive.137/140/TypOpenLoopWBiasTB/psf")
  openResults("/home/mseminario2/chips/castalia/simarchive/anatop_tb_controlamp/Interactive.137/140/TypOpenLoopWBiasTB/psf")
  when(member('ac results())
    selectResult('ac)
    mtxP = outfile("/home/mseminario2/vestarv/implementations/asic/castalia/analog/data/raw/ol_ac__ss.meta" "w")
    fprintf(mtxP "sweep %%L\n" car(errset(sweepNames())))
    close(mtxP)
    errset(mtxDump("/home/mseminario2/vestarv/implementations/asic/castalia/analog/data/raw/ol_ac__ss__a0_db.csv" dB20(value(v("/V_OutOL")/(v("/V_InP")-v("/V_InM")) 1e-3))))
    errset(mtxDump("/home/mseminario2/vestarv/implementations/asic/castalia/analog/data/raw/ol_ac__ss__a0_vv.csv" abs(value(v("/V_OutOL")/(v("/V_InP")-v("/V_InM")) 1e-3))))
    errset(mtxDump("/home/mseminario2/vestarv/implementations/asic/castalia/analog/data/raw/ol_ac__ss__av_db.csv" dB20(v("/V_OutOL")/(v("/V_InP")-v("/V_InM")))))
    errset(mtxDump("/home/mseminario2/vestarv/implementations/asic/castalia/analog/data/raw/ol_ac__ss__av_ph.csv" phaseDegUnwrapped(v("/V_OutOL")/(v("/V_InP")-v("/V_InM")))))
    errset(mtxDump("/home/mseminario2/vestarv/implementations/asic/castalia/analog/data/raw/ol_ac__ss__f3db.csv" bandwidth(v("/V_OutOL")/(v("/V_InP")-v("/V_InM")) 3 "low")))
    errset(mtxDump("/home/mseminario2/vestarv/implementations/asic/castalia/analog/data/raw/ol_ac__ss__gbw.csv" gainBwProd(v("/V_OutOL")/(v("/V_InP")-v("/V_InM")))))
    errset(mtxDump("/home/mseminario2/vestarv/implementations/asic/castalia/analog/data/raw/ol_ac__ss__ph_ugf.csv" value(phaseDegUnwrapped(v("/V_OutOL")/(v("/V_InP")-v("/V_InM"))) unityGainFreq(v("/V_OutOL")/(v("/V_InP")-v("/V_InM"))))))
    errset(mtxDump("/home/mseminario2/vestarv/implementations/asic/castalia/analog/data/raw/ol_ac__ss__ugf.csv" unityGainFreq(v("/V_OutOL")/(v("/V_InP")-v("/V_InM")))))
  )
)

;; ---- corner 140 (ss) / test ol_dc
when(isDir("/home/mseminario2/chips/castalia/simarchive/anatop_tb_controlamp/Interactive.137/140/TypOpenLoopWBiasTB/psf")
  openResults("/home/mseminario2/chips/castalia/simarchive/anatop_tb_controlamp/Interactive.137/140/TypOpenLoopWBiasTB/psf")
  when(member('dc results())
    selectResult('dc)
    mtxP = outfile("/home/mseminario2/vestarv/implementations/asic/castalia/analog/data/raw/ol_dc__ss.meta" "w")
    fprintf(mtxP "sweep %%L\n" car(errset(sweepNames())))
    close(mtxP)
    errset(mtxDump("/home/mseminario2/vestarv/implementations/asic/castalia/analog/data/raw/ol_dc__ss__idd.csv" abs(i("/POWER/SRC_VDD25/PLUS"))))
    errset(mtxDump("/home/mseminario2/vestarv/implementations/asic/castalia/analog/data/raw/ol_dc__ss__voh.csv" ymax(v("/V_OutOL"))))
    errset(mtxDump("/home/mseminario2/vestarv/implementations/asic/castalia/analog/data/raw/ol_dc__ss__vol.csv" ymin(v("/V_OutOL"))))
    errset(mtxDump("/home/mseminario2/vestarv/implementations/asic/castalia/analog/data/raw/ol_dc__ss__vos_ol.csv" cross(v("/V_OutOL") 1.25 1 "either")))
    errset(mtxDump("/home/mseminario2/vestarv/implementations/asic/castalia/analog/data/raw/ol_dc__ss__vout.csv" v("/V_OutOL")))
  )
)

printf("MTX_EXTRACT_DONE\n")
exit(0)
