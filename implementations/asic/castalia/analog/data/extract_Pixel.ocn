;; generated by maestro2tex -- do not edit
procedure(mtxDump(fname wv)
  let((xs ys n p)
    p = outfile(fname "w")
    cond(
      (null(wv) fprintf(p "#nil\n"))
      (drIsWaveform(wv)
        xs = drGetWaveformXVec(wv)
        ys = drGetWaveformYVec(wv)
        n = drVectorLength(xs)
        for(i 0 n-1
          fprintf(p "%.10g %.10g\n" drGetElem(xs i) drGetElem(ys i)))
      )
      (t fprintf(p "#scalar %.10g\n" float(wv)))
    )
    close(p)
    t))

;; ---- corner 81 (tt) / test px_acc35_dc
when(isDir("/home/mseminario2/chips/castalia/ic/.simulation/castalia/tb_anatop_pixel/maestro/results/maestro/Interactive.20/81/ps_iacc/psf")
  openResults("/home/mseminario2/chips/castalia/ic/.simulation/castalia/tb_anatop_pixel/maestro/results/maestro/Interactive.20/81/ps_iacc/psf")
  when(member('dc results())
    selectResult('dc)
    mtxP = outfile("/home/mseminario2/vestarv/implementations/asic/castalia/analog/data/raw/px_acc35_dc__tt.meta" "w")
    fprintf(mtxP "sweep %%L\n" car(errset(sweepNames())))
    close(mtxP)
    errset(mtxDump("/home/mseminario2/vestarv/implementations/asic/castalia/analog/data/raw/px_acc35_dc__tt__ierr_0.csv" value((((VS("/V_OUT") - VAR("V_CM")) / VAR("rf")) - xval(((VS("/V_OUT") - VAR("V_CM")) / VAR("rf")))) 0)))
    errset(mtxDump("/home/mseminario2/vestarv/implementations/asic/castalia/analog/data/raw/px_acc35_dc__tt__ierr_lsb.csv" ((((VS("/V_OUT") - VAR("V_CM")) / VAR("rf")) - xval(((VS("/V_OUT") - VAR("V_CM")) / VAR("rf")))) * VAR("rf") / 0.002441)))
    errset(mtxDump("/home/mseminario2/vestarv/implementations/asic/castalia/analog/data/raw/px_acc35_dc__tt__ierr_lsb_max.csv" ymax(abs(clip((((((VS("/V_OUT") - VAR("V_CM")) / VAR("rf")) - xval(((VS("/V_OUT") - VAR("V_CM")) / VAR("rf")))) * VAR("rf")) / 0.002441) (0 - (1.155 / VAR("rf"))) (1.155 / VAR("rf")))))))
    errset(mtxDump("/home/mseminario2/vestarv/implementations/asic/castalia/analog/data/raw/px_acc35_dc__tt__slope_err_0.csv" (value(deriv(((VS("/V_OUT") - VAR("V_CM")) / VAR("rf"))) 0) - 1)))
  )
)

;; ---- corner 81 (tt) / test px_ctrl_dc
when(isDir("/home/mseminario2/chips/castalia/ic/.simulation/castalia/tb_anatop_pixel/maestro/results/maestro/Interactive.20/81/PotCtrlTB/psf")
  openResults("/home/mseminario2/chips/castalia/ic/.simulation/castalia/tb_anatop_pixel/maestro/results/maestro/Interactive.20/81/PotCtrlTB/psf")
  when(member('dc results())
    selectResult('dc)
    mtxP = outfile("/home/mseminario2/vestarv/implementations/asic/castalia/analog/data/raw/px_ctrl_dc__tt.meta" "w")
    fprintf(mtxP "sweep %%L\n" car(errset(sweepNames())))
    close(mtxP)
    errset(mtxDump("/home/mseminario2/vestarv/implementations/asic/castalia/analog/data/raw/px_ctrl_dc__tt__ce_hi.csv" ymax(VS("/CE"))))
    errset(mtxDump("/home/mseminario2/vestarv/implementations/asic/castalia/analog/data/raw/px_ctrl_dc__tt__ce_lo.csv" ymin(VS("/CE"))))
    errset(mtxDump("/home/mseminario2/vestarv/implementations/asic/castalia/analog/data/raw/px_ctrl_dc__tt__ce_w.csv" VS("/CE")))
    errset(mtxDump("/home/mseminario2/vestarv/implementations/asic/castalia/analog/data/raw/px_ctrl_dc__tt__i_sink_max.csv" abs(ymin(IS("/IPRB_F/PLUS")))))
    errset(mtxDump("/home/mseminario2/vestarv/implementations/asic/castalia/analog/data/raw/px_ctrl_dc__tt__i_src_max.csv" ymax(IS("/IPRB_F/PLUS"))))
    errset(mtxDump("/home/mseminario2/vestarv/implementations/asic/castalia/analog/data/raw/px_ctrl_dc__tt__i_tot.csv" abs(IDC("/POWER/SRC_VDD25/PLUS"))))
    errset(mtxDump("/home/mseminario2/vestarv/implementations/asic/castalia/analog/data/raw/px_ctrl_dc__tt__re_err_0.csv" value((VS("/RE") - xval(VS("/RE"))) VAR("V_CM"))))
    errset(mtxDump("/home/mseminario2/vestarv/implementations/asic/castalia/analog/data/raw/px_ctrl_dc__tt__re_err_max.csv" ymax(abs(clip((VS("/RE") - xval(VS("/RE"))) VAR("vref_lo") VAR("vref_hi"))))))
    errset(mtxDump("/home/mseminario2/vestarv/implementations/asic/castalia/analog/data/raw/px_ctrl_dc__tt__re_err_slope.csv" ymax(abs(deriv(clip((VS("/RE") - xval(VS("/RE"))) VAR("vref_lo") VAR("vref_hi")))))))
    errset(mtxDump("/home/mseminario2/vestarv/implementations/asic/castalia/analog/data/raw/px_ctrl_dc__tt__vref_hi_meas.csv" cross(abs((VS("/RE") - xval(VS("/RE")))) 0.01 1 "rising")))
    errset(mtxDump("/home/mseminario2/vestarv/implementations/asic/castalia/analog/data/raw/px_ctrl_dc__tt__vref_lo_meas.csv" cross(abs((VS("/RE") - xval(VS("/RE")))) 0.01 1 "falling")))
    errset(mtxDump("/home/mseminario2/vestarv/implementations/asic/castalia/analog/data/raw/px_ctrl_dc__tt__vref_range.csv" (cross(abs((VS("/RE") - xval(VS("/RE")))) 0.01 1 "rising") - cross(abs((VS("/RE") - xval(VS("/RE")))) 0.01 1 "falling"))))
    errset(mtxDump("/home/mseminario2/vestarv/implementations/asic/castalia/analog/data/raw/px_ctrl_dc__tt__we_range.csv" (cross(abs((VS("/WE") - VAR("V_CM"))) 0.01 1 "rising") - cross(abs((VS("/WE") - VAR("V_CM"))) 0.01 1 "falling"))))
  )
)

;; ---- corner 81 (tt) / test px_ctrl_stb
when(isDir("/home/mseminario2/chips/castalia/ic/.simulation/castalia/tb_anatop_pixel/maestro/results/maestro/Interactive.20/81/PotCtrlTB/psf")
  openResults("/home/mseminario2/chips/castalia/ic/.simulation/castalia/tb_anatop_pixel/maestro/results/maestro/Interactive.20/81/PotCtrlTB/psf")
  when(member('stb results())
    selectResult('stb)
    mtxP = outfile("/home/mseminario2/vestarv/implementations/asic/castalia/analog/data/raw/px_ctrl_stb__tt.meta" "w")
    fprintf(mtxP "sweep %%L\n" car(errset(sweepNames())))
    close(mtxP)
    errset(mtxDump("/home/mseminario2/vestarv/implementations/asic/castalia/analog/data/raw/px_ctrl_stb__tt__aol_db.csv" ymax(dB20(getData("loopGain" ?result "stb")))))
    errset(mtxDump("/home/mseminario2/vestarv/implementations/asic/castalia/analog/data/raw/px_ctrl_stb__tt__lg_db.csv" dB20(getData("loopGain" ?result "stb"))))
    errset(mtxDump("/home/mseminario2/vestarv/implementations/asic/castalia/analog/data/raw/px_ctrl_stb__tt__pm.csv" value(phase(getData("loopGain" ?result "stb")) cross(dB20(getData("loopGain" ?result "stb")) 0 1 "falling"))))
    errset(mtxDump("/home/mseminario2/vestarv/implementations/asic/castalia/analog/data/raw/px_ctrl_stb__tt__ugf.csv" cross(dB20(getData("loopGain" ?result "stb")) 0 1 "falling")))
  )
)

;; ---- corner 82 (ff) / test px_acc35_dc
when(isDir("/home/mseminario2/chips/castalia/ic/.simulation/castalia/tb_anatop_pixel/maestro/results/maestro/Interactive.20/82/ps_iacc/psf")
  openResults("/home/mseminario2/chips/castalia/ic/.simulation/castalia/tb_anatop_pixel/maestro/results/maestro/Interactive.20/82/ps_iacc/psf")
  when(member('dc results())
    selectResult('dc)
    mtxP = outfile("/home/mseminario2/vestarv/implementations/asic/castalia/analog/data/raw/px_acc35_dc__ff.meta" "w")
    fprintf(mtxP "sweep %%L\n" car(errset(sweepNames())))
    close(mtxP)
    errset(mtxDump("/home/mseminario2/vestarv/implementations/asic/castalia/analog/data/raw/px_acc35_dc__ff__ierr_0.csv" value((((VS("/V_OUT") - VAR("V_CM")) / VAR("rf")) - xval(((VS("/V_OUT") - VAR("V_CM")) / VAR("rf")))) 0)))
    errset(mtxDump("/home/mseminario2/vestarv/implementations/asic/castalia/analog/data/raw/px_acc35_dc__ff__ierr_lsb.csv" ((((VS("/V_OUT") - VAR("V_CM")) / VAR("rf")) - xval(((VS("/V_OUT") - VAR("V_CM")) / VAR("rf")))) * VAR("rf") / 0.002441)))
    errset(mtxDump("/home/mseminario2/vestarv/implementations/asic/castalia/analog/data/raw/px_acc35_dc__ff__ierr_lsb_max.csv" ymax(abs(clip((((((VS("/V_OUT") - VAR("V_CM")) / VAR("rf")) - xval(((VS("/V_OUT") - VAR("V_CM")) / VAR("rf")))) * VAR("rf")) / 0.002441) (0 - (1.155 / VAR("rf"))) (1.155 / VAR("rf")))))))
    errset(mtxDump("/home/mseminario2/vestarv/implementations/asic/castalia/analog/data/raw/px_acc35_dc__ff__slope_err_0.csv" (value(deriv(((VS("/V_OUT") - VAR("V_CM")) / VAR("rf"))) 0) - 1)))
  )
)

;; ---- corner 82 (ff) / test px_ctrl_dc
when(isDir("/home/mseminario2/chips/castalia/ic/.simulation/castalia/tb_anatop_pixel/maestro/results/maestro/Interactive.20/82/PotCtrlTB/psf")
  openResults("/home/mseminario2/chips/castalia/ic/.simulation/castalia/tb_anatop_pixel/maestro/results/maestro/Interactive.20/82/PotCtrlTB/psf")
  when(member('dc results())
    selectResult('dc)
    mtxP = outfile("/home/mseminario2/vestarv/implementations/asic/castalia/analog/data/raw/px_ctrl_dc__ff.meta" "w")
    fprintf(mtxP "sweep %%L\n" car(errset(sweepNames())))
    close(mtxP)
    errset(mtxDump("/home/mseminario2/vestarv/implementations/asic/castalia/analog/data/raw/px_ctrl_dc__ff__ce_hi.csv" ymax(VS("/CE"))))
    errset(mtxDump("/home/mseminario2/vestarv/implementations/asic/castalia/analog/data/raw/px_ctrl_dc__ff__ce_lo.csv" ymin(VS("/CE"))))
    errset(mtxDump("/home/mseminario2/vestarv/implementations/asic/castalia/analog/data/raw/px_ctrl_dc__ff__ce_w.csv" VS("/CE")))
    errset(mtxDump("/home/mseminario2/vestarv/implementations/asic/castalia/analog/data/raw/px_ctrl_dc__ff__i_sink_max.csv" abs(ymin(IS("/IPRB_F/PLUS")))))
    errset(mtxDump("/home/mseminario2/vestarv/implementations/asic/castalia/analog/data/raw/px_ctrl_dc__ff__i_src_max.csv" ymax(IS("/IPRB_F/PLUS"))))
    errset(mtxDump("/home/mseminario2/vestarv/implementations/asic/castalia/analog/data/raw/px_ctrl_dc__ff__i_tot.csv" abs(IDC("/POWER/SRC_VDD25/PLUS"))))
    errset(mtxDump("/home/mseminario2/vestarv/implementations/asic/castalia/analog/data/raw/px_ctrl_dc__ff__re_err_0.csv" value((VS("/RE") - xval(VS("/RE"))) VAR("V_CM"))))
    errset(mtxDump("/home/mseminario2/vestarv/implementations/asic/castalia/analog/data/raw/px_ctrl_dc__ff__re_err_max.csv" ymax(abs(clip((VS("/RE") - xval(VS("/RE"))) VAR("vref_lo") VAR("vref_hi"))))))
    errset(mtxDump("/home/mseminario2/vestarv/implementations/asic/castalia/analog/data/raw/px_ctrl_dc__ff__re_err_slope.csv" ymax(abs(deriv(clip((VS("/RE") - xval(VS("/RE"))) VAR("vref_lo") VAR("vref_hi")))))))
    errset(mtxDump("/home/mseminario2/vestarv/implementations/asic/castalia/analog/data/raw/px_ctrl_dc__ff__vref_hi_meas.csv" cross(abs((VS("/RE") - xval(VS("/RE")))) 0.01 1 "rising")))
    errset(mtxDump("/home/mseminario2/vestarv/implementations/asic/castalia/analog/data/raw/px_ctrl_dc__ff__vref_lo_meas.csv" cross(abs((VS("/RE") - xval(VS("/RE")))) 0.01 1 "falling")))
    errset(mtxDump("/home/mseminario2/vestarv/implementations/asic/castalia/analog/data/raw/px_ctrl_dc__ff__vref_range.csv" (cross(abs((VS("/RE") - xval(VS("/RE")))) 0.01 1 "rising") - cross(abs((VS("/RE") - xval(VS("/RE")))) 0.01 1 "falling"))))
    errset(mtxDump("/home/mseminario2/vestarv/implementations/asic/castalia/analog/data/raw/px_ctrl_dc__ff__we_range.csv" (cross(abs((VS("/WE") - VAR("V_CM"))) 0.01 1 "rising") - cross(abs((VS("/WE") - VAR("V_CM"))) 0.01 1 "falling"))))
  )
)

;; ---- corner 82 (ff) / test px_ctrl_stb
when(isDir("/home/mseminario2/chips/castalia/ic/.simulation/castalia/tb_anatop_pixel/maestro/results/maestro/Interactive.20/82/PotCtrlTB/psf")
  openResults("/home/mseminario2/chips/castalia/ic/.simulation/castalia/tb_anatop_pixel/maestro/results/maestro/Interactive.20/82/PotCtrlTB/psf")
  when(member('stb results())
    selectResult('stb)
    mtxP = outfile("/home/mseminario2/vestarv/implementations/asic/castalia/analog/data/raw/px_ctrl_stb__ff.meta" "w")
    fprintf(mtxP "sweep %%L\n" car(errset(sweepNames())))
    close(mtxP)
    errset(mtxDump("/home/mseminario2/vestarv/implementations/asic/castalia/analog/data/raw/px_ctrl_stb__ff__aol_db.csv" ymax(dB20(getData("loopGain" ?result "stb")))))
    errset(mtxDump("/home/mseminario2/vestarv/implementations/asic/castalia/analog/data/raw/px_ctrl_stb__ff__lg_db.csv" dB20(getData("loopGain" ?result "stb"))))
    errset(mtxDump("/home/mseminario2/vestarv/implementations/asic/castalia/analog/data/raw/px_ctrl_stb__ff__pm.csv" value(phase(getData("loopGain" ?result "stb")) cross(dB20(getData("loopGain" ?result "stb")) 0 1 "falling"))))
    errset(mtxDump("/home/mseminario2/vestarv/implementations/asic/castalia/analog/data/raw/px_ctrl_stb__ff__ugf.csv" cross(dB20(getData("loopGain" ?result "stb")) 0 1 "falling")))
  )
)

;; ---- corner 83 (fs) / test px_acc35_dc
when(isDir("/home/mseminario2/chips/castalia/ic/.simulation/castalia/tb_anatop_pixel/maestro/results/maestro/Interactive.20/83/ps_iacc/psf")
  openResults("/home/mseminario2/chips/castalia/ic/.simulation/castalia/tb_anatop_pixel/maestro/results/maestro/Interactive.20/83/ps_iacc/psf")
  when(member('dc results())
    selectResult('dc)
    mtxP = outfile("/home/mseminario2/vestarv/implementations/asic/castalia/analog/data/raw/px_acc35_dc__fs.meta" "w")
    fprintf(mtxP "sweep %%L\n" car(errset(sweepNames())))
    close(mtxP)
    errset(mtxDump("/home/mseminario2/vestarv/implementations/asic/castalia/analog/data/raw/px_acc35_dc__fs__ierr_0.csv" value((((VS("/V_OUT") - VAR("V_CM")) / VAR("rf")) - xval(((VS("/V_OUT") - VAR("V_CM")) / VAR("rf")))) 0)))
    errset(mtxDump("/home/mseminario2/vestarv/implementations/asic/castalia/analog/data/raw/px_acc35_dc__fs__ierr_lsb.csv" ((((VS("/V_OUT") - VAR("V_CM")) / VAR("rf")) - xval(((VS("/V_OUT") - VAR("V_CM")) / VAR("rf")))) * VAR("rf") / 0.002441)))
    errset(mtxDump("/home/mseminario2/vestarv/implementations/asic/castalia/analog/data/raw/px_acc35_dc__fs__ierr_lsb_max.csv" ymax(abs(clip((((((VS("/V_OUT") - VAR("V_CM")) / VAR("rf")) - xval(((VS("/V_OUT") - VAR("V_CM")) / VAR("rf")))) * VAR("rf")) / 0.002441) (0 - (1.155 / VAR("rf"))) (1.155 / VAR("rf")))))))
    errset(mtxDump("/home/mseminario2/vestarv/implementations/asic/castalia/analog/data/raw/px_acc35_dc__fs__slope_err_0.csv" (value(deriv(((VS("/V_OUT") - VAR("V_CM")) / VAR("rf"))) 0) - 1)))
  )
)

;; ---- corner 83 (fs) / test px_ctrl_dc
when(isDir("/home/mseminario2/chips/castalia/ic/.simulation/castalia/tb_anatop_pixel/maestro/results/maestro/Interactive.20/83/PotCtrlTB/psf")
  openResults("/home/mseminario2/chips/castalia/ic/.simulation/castalia/tb_anatop_pixel/maestro/results/maestro/Interactive.20/83/PotCtrlTB/psf")
  when(member('dc results())
    selectResult('dc)
    mtxP = outfile("/home/mseminario2/vestarv/implementations/asic/castalia/analog/data/raw/px_ctrl_dc__fs.meta" "w")
    fprintf(mtxP "sweep %%L\n" car(errset(sweepNames())))
    close(mtxP)
    errset(mtxDump("/home/mseminario2/vestarv/implementations/asic/castalia/analog/data/raw/px_ctrl_dc__fs__ce_hi.csv" ymax(VS("/CE"))))
    errset(mtxDump("/home/mseminario2/vestarv/implementations/asic/castalia/analog/data/raw/px_ctrl_dc__fs__ce_lo.csv" ymin(VS("/CE"))))
    errset(mtxDump("/home/mseminario2/vestarv/implementations/asic/castalia/analog/data/raw/px_ctrl_dc__fs__ce_w.csv" VS("/CE")))
    errset(mtxDump("/home/mseminario2/vestarv/implementations/asic/castalia/analog/data/raw/px_ctrl_dc__fs__i_sink_max.csv" abs(ymin(IS("/IPRB_F/PLUS")))))
    errset(mtxDump("/home/mseminario2/vestarv/implementations/asic/castalia/analog/data/raw/px_ctrl_dc__fs__i_src_max.csv" ymax(IS("/IPRB_F/PLUS"))))
    errset(mtxDump("/home/mseminario2/vestarv/implementations/asic/castalia/analog/data/raw/px_ctrl_dc__fs__i_tot.csv" abs(IDC("/POWER/SRC_VDD25/PLUS"))))
    errset(mtxDump("/home/mseminario2/vestarv/implementations/asic/castalia/analog/data/raw/px_ctrl_dc__fs__re_err_0.csv" value((VS("/RE") - xval(VS("/RE"))) VAR("V_CM"))))
    errset(mtxDump("/home/mseminario2/vestarv/implementations/asic/castalia/analog/data/raw/px_ctrl_dc__fs__re_err_max.csv" ymax(abs(clip((VS("/RE") - xval(VS("/RE"))) VAR("vref_lo") VAR("vref_hi"))))))
    errset(mtxDump("/home/mseminario2/vestarv/implementations/asic/castalia/analog/data/raw/px_ctrl_dc__fs__re_err_slope.csv" ymax(abs(deriv(clip((VS("/RE") - xval(VS("/RE"))) VAR("vref_lo") VAR("vref_hi")))))))
    errset(mtxDump("/home/mseminario2/vestarv/implementations/asic/castalia/analog/data/raw/px_ctrl_dc__fs__vref_hi_meas.csv" cross(abs((VS("/RE") - xval(VS("/RE")))) 0.01 1 "rising")))
    errset(mtxDump("/home/mseminario2/vestarv/implementations/asic/castalia/analog/data/raw/px_ctrl_dc__fs__vref_lo_meas.csv" cross(abs((VS("/RE") - xval(VS("/RE")))) 0.01 1 "falling")))
    errset(mtxDump("/home/mseminario2/vestarv/implementations/asic/castalia/analog/data/raw/px_ctrl_dc__fs__vref_range.csv" (cross(abs((VS("/RE") - xval(VS("/RE")))) 0.01 1 "rising") - cross(abs((VS("/RE") - xval(VS("/RE")))) 0.01 1 "falling"))))
    errset(mtxDump("/home/mseminario2/vestarv/implementations/asic/castalia/analog/data/raw/px_ctrl_dc__fs__we_range.csv" (cross(abs((VS("/WE") - VAR("V_CM"))) 0.01 1 "rising") - cross(abs((VS("/WE") - VAR("V_CM"))) 0.01 1 "falling"))))
  )
)

;; ---- corner 83 (fs) / test px_ctrl_stb
when(isDir("/home/mseminario2/chips/castalia/ic/.simulation/castalia/tb_anatop_pixel/maestro/results/maestro/Interactive.20/83/PotCtrlTB/psf")
  openResults("/home/mseminario2/chips/castalia/ic/.simulation/castalia/tb_anatop_pixel/maestro/results/maestro/Interactive.20/83/PotCtrlTB/psf")
  when(member('stb results())
    selectResult('stb)
    mtxP = outfile("/home/mseminario2/vestarv/implementations/asic/castalia/analog/data/raw/px_ctrl_stb__fs.meta" "w")
    fprintf(mtxP "sweep %%L\n" car(errset(sweepNames())))
    close(mtxP)
    errset(mtxDump("/home/mseminario2/vestarv/implementations/asic/castalia/analog/data/raw/px_ctrl_stb__fs__aol_db.csv" ymax(dB20(getData("loopGain" ?result "stb")))))
    errset(mtxDump("/home/mseminario2/vestarv/implementations/asic/castalia/analog/data/raw/px_ctrl_stb__fs__lg_db.csv" dB20(getData("loopGain" ?result "stb"))))
    errset(mtxDump("/home/mseminario2/vestarv/implementations/asic/castalia/analog/data/raw/px_ctrl_stb__fs__pm.csv" value(phase(getData("loopGain" ?result "stb")) cross(dB20(getData("loopGain" ?result "stb")) 0 1 "falling"))))
    errset(mtxDump("/home/mseminario2/vestarv/implementations/asic/castalia/analog/data/raw/px_ctrl_stb__fs__ugf.csv" cross(dB20(getData("loopGain" ?result "stb")) 0 1 "falling")))
  )
)

;; ---- corner 84 (sf) / test px_acc35_dc
when(isDir("/home/mseminario2/chips/castalia/ic/.simulation/castalia/tb_anatop_pixel/maestro/results/maestro/Interactive.20/84/ps_iacc/psf")
  openResults("/home/mseminario2/chips/castalia/ic/.simulation/castalia/tb_anatop_pixel/maestro/results/maestro/Interactive.20/84/ps_iacc/psf")
  when(member('dc results())
    selectResult('dc)
    mtxP = outfile("/home/mseminario2/vestarv/implementations/asic/castalia/analog/data/raw/px_acc35_dc__sf.meta" "w")
    fprintf(mtxP "sweep %%L\n" car(errset(sweepNames())))
    close(mtxP)
    errset(mtxDump("/home/mseminario2/vestarv/implementations/asic/castalia/analog/data/raw/px_acc35_dc__sf__ierr_0.csv" value((((VS("/V_OUT") - VAR("V_CM")) / VAR("rf")) - xval(((VS("/V_OUT") - VAR("V_CM")) / VAR("rf")))) 0)))
    errset(mtxDump("/home/mseminario2/vestarv/implementations/asic/castalia/analog/data/raw/px_acc35_dc__sf__ierr_lsb.csv" ((((VS("/V_OUT") - VAR("V_CM")) / VAR("rf")) - xval(((VS("/V_OUT") - VAR("V_CM")) / VAR("rf")))) * VAR("rf") / 0.002441)))
    errset(mtxDump("/home/mseminario2/vestarv/implementations/asic/castalia/analog/data/raw/px_acc35_dc__sf__ierr_lsb_max.csv" ymax(abs(clip((((((VS("/V_OUT") - VAR("V_CM")) / VAR("rf")) - xval(((VS("/V_OUT") - VAR("V_CM")) / VAR("rf")))) * VAR("rf")) / 0.002441) (0 - (1.155 / VAR("rf"))) (1.155 / VAR("rf")))))))
    errset(mtxDump("/home/mseminario2/vestarv/implementations/asic/castalia/analog/data/raw/px_acc35_dc__sf__slope_err_0.csv" (value(deriv(((VS("/V_OUT") - VAR("V_CM")) / VAR("rf"))) 0) - 1)))
  )
)

;; ---- corner 84 (sf) / test px_ctrl_dc
when(isDir("/home/mseminario2/chips/castalia/ic/.simulation/castalia/tb_anatop_pixel/maestro/results/maestro/Interactive.20/84/PotCtrlTB/psf")
  openResults("/home/mseminario2/chips/castalia/ic/.simulation/castalia/tb_anatop_pixel/maestro/results/maestro/Interactive.20/84/PotCtrlTB/psf")
  when(member('dc results())
    selectResult('dc)
    mtxP = outfile("/home/mseminario2/vestarv/implementations/asic/castalia/analog/data/raw/px_ctrl_dc__sf.meta" "w")
    fprintf(mtxP "sweep %%L\n" car(errset(sweepNames())))
    close(mtxP)
    errset(mtxDump("/home/mseminario2/vestarv/implementations/asic/castalia/analog/data/raw/px_ctrl_dc__sf__ce_hi.csv" ymax(VS("/CE"))))
    errset(mtxDump("/home/mseminario2/vestarv/implementations/asic/castalia/analog/data/raw/px_ctrl_dc__sf__ce_lo.csv" ymin(VS("/CE"))))
    errset(mtxDump("/home/mseminario2/vestarv/implementations/asic/castalia/analog/data/raw/px_ctrl_dc__sf__ce_w.csv" VS("/CE")))
    errset(mtxDump("/home/mseminario2/vestarv/implementations/asic/castalia/analog/data/raw/px_ctrl_dc__sf__i_sink_max.csv" abs(ymin(IS("/IPRB_F/PLUS")))))
    errset(mtxDump("/home/mseminario2/vestarv/implementations/asic/castalia/analog/data/raw/px_ctrl_dc__sf__i_src_max.csv" ymax(IS("/IPRB_F/PLUS"))))
    errset(mtxDump("/home/mseminario2/vestarv/implementations/asic/castalia/analog/data/raw/px_ctrl_dc__sf__i_tot.csv" abs(IDC("/POWER/SRC_VDD25/PLUS"))))
    errset(mtxDump("/home/mseminario2/vestarv/implementations/asic/castalia/analog/data/raw/px_ctrl_dc__sf__re_err_0.csv" value((VS("/RE") - xval(VS("/RE"))) VAR("V_CM"))))
    errset(mtxDump("/home/mseminario2/vestarv/implementations/asic/castalia/analog/data/raw/px_ctrl_dc__sf__re_err_max.csv" ymax(abs(clip((VS("/RE") - xval(VS("/RE"))) VAR("vref_lo") VAR("vref_hi"))))))
    errset(mtxDump("/home/mseminario2/vestarv/implementations/asic/castalia/analog/data/raw/px_ctrl_dc__sf__re_err_slope.csv" ymax(abs(deriv(clip((VS("/RE") - xval(VS("/RE"))) VAR("vref_lo") VAR("vref_hi")))))))
    errset(mtxDump("/home/mseminario2/vestarv/implementations/asic/castalia/analog/data/raw/px_ctrl_dc__sf__vref_hi_meas.csv" cross(abs((VS("/RE") - xval(VS("/RE")))) 0.01 1 "rising")))
    errset(mtxDump("/home/mseminario2/vestarv/implementations/asic/castalia/analog/data/raw/px_ctrl_dc__sf__vref_lo_meas.csv" cross(abs((VS("/RE") - xval(VS("/RE")))) 0.01 1 "falling")))
    errset(mtxDump("/home/mseminario2/vestarv/implementations/asic/castalia/analog/data/raw/px_ctrl_dc__sf__vref_range.csv" (cross(abs((VS("/RE") - xval(VS("/RE")))) 0.01 1 "rising") - cross(abs((VS("/RE") - xval(VS("/RE")))) 0.01 1 "falling"))))
    errset(mtxDump("/home/mseminario2/vestarv/implementations/asic/castalia/analog/data/raw/px_ctrl_dc__sf__we_range.csv" (cross(abs((VS("/WE") - VAR("V_CM"))) 0.01 1 "rising") - cross(abs((VS("/WE") - VAR("V_CM"))) 0.01 1 "falling"))))
  )
)

;; ---- corner 84 (sf) / test px_ctrl_stb
when(isDir("/home/mseminario2/chips/castalia/ic/.simulation/castalia/tb_anatop_pixel/maestro/results/maestro/Interactive.20/84/PotCtrlTB/psf")
  openResults("/home/mseminario2/chips/castalia/ic/.simulation/castalia/tb_anatop_pixel/maestro/results/maestro/Interactive.20/84/PotCtrlTB/psf")
  when(member('stb results())
    selectResult('stb)
    mtxP = outfile("/home/mseminario2/vestarv/implementations/asic/castalia/analog/data/raw/px_ctrl_stb__sf.meta" "w")
    fprintf(mtxP "sweep %%L\n" car(errset(sweepNames())))
    close(mtxP)
    errset(mtxDump("/home/mseminario2/vestarv/implementations/asic/castalia/analog/data/raw/px_ctrl_stb__sf__aol_db.csv" ymax(dB20(getData("loopGain" ?result "stb")))))
    errset(mtxDump("/home/mseminario2/vestarv/implementations/asic/castalia/analog/data/raw/px_ctrl_stb__sf__lg_db.csv" dB20(getData("loopGain" ?result "stb"))))
    errset(mtxDump("/home/mseminario2/vestarv/implementations/asic/castalia/analog/data/raw/px_ctrl_stb__sf__pm.csv" value(phase(getData("loopGain" ?result "stb")) cross(dB20(getData("loopGain" ?result "stb")) 0 1 "falling"))))
    errset(mtxDump("/home/mseminario2/vestarv/implementations/asic/castalia/analog/data/raw/px_ctrl_stb__sf__ugf.csv" cross(dB20(getData("loopGain" ?result "stb")) 0 1 "falling")))
  )
)

;; ---- corner 85 (ss) / test px_acc35_dc
when(isDir("/home/mseminario2/chips/castalia/ic/.simulation/castalia/tb_anatop_pixel/maestro/results/maestro/Interactive.20/85/ps_iacc/psf")
  openResults("/home/mseminario2/chips/castalia/ic/.simulation/castalia/tb_anatop_pixel/maestro/results/maestro/Interactive.20/85/ps_iacc/psf")
  when(member('dc results())
    selectResult('dc)
    mtxP = outfile("/home/mseminario2/vestarv/implementations/asic/castalia/analog/data/raw/px_acc35_dc__ss.meta" "w")
    fprintf(mtxP "sweep %%L\n" car(errset(sweepNames())))
    close(mtxP)
    errset(mtxDump("/home/mseminario2/vestarv/implementations/asic/castalia/analog/data/raw/px_acc35_dc__ss__ierr_0.csv" value((((VS("/V_OUT") - VAR("V_CM")) / VAR("rf")) - xval(((VS("/V_OUT") - VAR("V_CM")) / VAR("rf")))) 0)))
    errset(mtxDump("/home/mseminario2/vestarv/implementations/asic/castalia/analog/data/raw/px_acc35_dc__ss__ierr_lsb.csv" ((((VS("/V_OUT") - VAR("V_CM")) / VAR("rf")) - xval(((VS("/V_OUT") - VAR("V_CM")) / VAR("rf")))) * VAR("rf") / 0.002441)))
    errset(mtxDump("/home/mseminario2/vestarv/implementations/asic/castalia/analog/data/raw/px_acc35_dc__ss__ierr_lsb_max.csv" ymax(abs(clip((((((VS("/V_OUT") - VAR("V_CM")) / VAR("rf")) - xval(((VS("/V_OUT") - VAR("V_CM")) / VAR("rf")))) * VAR("rf")) / 0.002441) (0 - (1.155 / VAR("rf"))) (1.155 / VAR("rf")))))))
    errset(mtxDump("/home/mseminario2/vestarv/implementations/asic/castalia/analog/data/raw/px_acc35_dc__ss__slope_err_0.csv" (value(deriv(((VS("/V_OUT") - VAR("V_CM")) / VAR("rf"))) 0) - 1)))
  )
)

;; ---- corner 85 (ss) / test px_ctrl_dc
when(isDir("/home/mseminario2/chips/castalia/ic/.simulation/castalia/tb_anatop_pixel/maestro/results/maestro/Interactive.20/85/PotCtrlTB/psf")
  openResults("/home/mseminario2/chips/castalia/ic/.simulation/castalia/tb_anatop_pixel/maestro/results/maestro/Interactive.20/85/PotCtrlTB/psf")
  when(member('dc results())
    selectResult('dc)
    mtxP = outfile("/home/mseminario2/vestarv/implementations/asic/castalia/analog/data/raw/px_ctrl_dc__ss.meta" "w")
    fprintf(mtxP "sweep %%L\n" car(errset(sweepNames())))
    close(mtxP)
    errset(mtxDump("/home/mseminario2/vestarv/implementations/asic/castalia/analog/data/raw/px_ctrl_dc__ss__ce_hi.csv" ymax(VS("/CE"))))
    errset(mtxDump("/home/mseminario2/vestarv/implementations/asic/castalia/analog/data/raw/px_ctrl_dc__ss__ce_lo.csv" ymin(VS("/CE"))))
    errset(mtxDump("/home/mseminario2/vestarv/implementations/asic/castalia/analog/data/raw/px_ctrl_dc__ss__ce_w.csv" VS("/CE")))
    errset(mtxDump("/home/mseminario2/vestarv/implementations/asic/castalia/analog/data/raw/px_ctrl_dc__ss__i_sink_max.csv" abs(ymin(IS("/IPRB_F/PLUS")))))
    errset(mtxDump("/home/mseminario2/vestarv/implementations/asic/castalia/analog/data/raw/px_ctrl_dc__ss__i_src_max.csv" ymax(IS("/IPRB_F/PLUS"))))
    errset(mtxDump("/home/mseminario2/vestarv/implementations/asic/castalia/analog/data/raw/px_ctrl_dc__ss__i_tot.csv" abs(IDC("/POWER/SRC_VDD25/PLUS"))))
    errset(mtxDump("/home/mseminario2/vestarv/implementations/asic/castalia/analog/data/raw/px_ctrl_dc__ss__re_err_0.csv" value((VS("/RE") - xval(VS("/RE"))) VAR("V_CM"))))
    errset(mtxDump("/home/mseminario2/vestarv/implementations/asic/castalia/analog/data/raw/px_ctrl_dc__ss__re_err_max.csv" ymax(abs(clip((VS("/RE") - xval(VS("/RE"))) VAR("vref_lo") VAR("vref_hi"))))))
    errset(mtxDump("/home/mseminario2/vestarv/implementations/asic/castalia/analog/data/raw/px_ctrl_dc__ss__re_err_slope.csv" ymax(abs(deriv(clip((VS("/RE") - xval(VS("/RE"))) VAR("vref_lo") VAR("vref_hi")))))))
    errset(mtxDump("/home/mseminario2/vestarv/implementations/asic/castalia/analog/data/raw/px_ctrl_dc__ss__vref_hi_meas.csv" cross(abs((VS("/RE") - xval(VS("/RE")))) 0.01 1 "rising")))
    errset(mtxDump("/home/mseminario2/vestarv/implementations/asic/castalia/analog/data/raw/px_ctrl_dc__ss__vref_lo_meas.csv" cross(abs((VS("/RE") - xval(VS("/RE")))) 0.01 1 "falling")))
    errset(mtxDump("/home/mseminario2/vestarv/implementations/asic/castalia/analog/data/raw/px_ctrl_dc__ss__vref_range.csv" (cross(abs((VS("/RE") - xval(VS("/RE")))) 0.01 1 "rising") - cross(abs((VS("/RE") - xval(VS("/RE")))) 0.01 1 "falling"))))
    errset(mtxDump("/home/mseminario2/vestarv/implementations/asic/castalia/analog/data/raw/px_ctrl_dc__ss__we_range.csv" (cross(abs((VS("/WE") - VAR("V_CM"))) 0.01 1 "rising") - cross(abs((VS("/WE") - VAR("V_CM"))) 0.01 1 "falling"))))
  )
)

;; ---- corner 85 (ss) / test px_ctrl_stb
when(isDir("/home/mseminario2/chips/castalia/ic/.simulation/castalia/tb_anatop_pixel/maestro/results/maestro/Interactive.20/85/PotCtrlTB/psf")
  openResults("/home/mseminario2/chips/castalia/ic/.simulation/castalia/tb_anatop_pixel/maestro/results/maestro/Interactive.20/85/PotCtrlTB/psf")
  when(member('stb results())
    selectResult('stb)
    mtxP = outfile("/home/mseminario2/vestarv/implementations/asic/castalia/analog/data/raw/px_ctrl_stb__ss.meta" "w")
    fprintf(mtxP "sweep %%L\n" car(errset(sweepNames())))
    close(mtxP)
    errset(mtxDump("/home/mseminario2/vestarv/implementations/asic/castalia/analog/data/raw/px_ctrl_stb__ss__aol_db.csv" ymax(dB20(getData("loopGain" ?result "stb")))))
    errset(mtxDump("/home/mseminario2/vestarv/implementations/asic/castalia/analog/data/raw/px_ctrl_stb__ss__lg_db.csv" dB20(getData("loopGain" ?result "stb"))))
    errset(mtxDump("/home/mseminario2/vestarv/implementations/asic/castalia/analog/data/raw/px_ctrl_stb__ss__pm.csv" value(phase(getData("loopGain" ?result "stb")) cross(dB20(getData("loopGain" ?result "stb")) 0 1 "falling"))))
    errset(mtxDump("/home/mseminario2/vestarv/implementations/asic/castalia/analog/data/raw/px_ctrl_stb__ss__ugf.csv" cross(dB20(getData("loopGain" ?result "stb")) 0 1 "falling")))
  )
)

printf("MTX_EXTRACT_DONE\n")
exit(0)
