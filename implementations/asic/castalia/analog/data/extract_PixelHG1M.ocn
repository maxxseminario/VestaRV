;; generated by maestro2tex -- do not edit
procedure(mtxDump(fname wv)
  let((xs ys n p)
    p = outfile(fname "w")
    cond(
      (null(wv) fprintf(p "#nil\n"))
      (drIsWaveform(wv)
        xs = drGetWaveformXVec(wv)
        ys = drGetWaveformYVec(wv)
        n = drVectorLength(xs)
        for(i 0 n-1
          fprintf(p "%.10g %.10g\n" drGetElem(xs i) drGetElem(ys i)))
      )
      (t fprintf(p "#scalar %.10g\n" float(wv)))
    )
    close(p)
    t))

;; ---- corner 1 (tt) / test px_hg1m_dc
when(isDir("/home/mseminario2/chips/castalia/simruns/tb_anatop_pixel_iacc_hg_1M_corners/castalia/tb_anatop_pixel/maestro/results/maestro/Ocean.0/1/ps_iacc_hg/psf")
  openResults("/home/mseminario2/chips/castalia/simruns/tb_anatop_pixel_iacc_hg_1M_corners/castalia/tb_anatop_pixel/maestro/results/maestro/Ocean.0/1/ps_iacc_hg/psf")
  when(member('dc results())
    selectResult('dc)
    mtxP = outfile("/home/mseminario2/vestarv/implementations/asic/castalia/analog/data/raw/px_hg1m_dc__tt.meta" "w")
    fprintf(mtxP "sweep %%L\n" car(errset(sweepNames())))
    close(mtxP)
    errset(mtxDump("/home/mseminario2/vestarv/implementations/asic/castalia/analog/data/raw/px_hg1m_dc__tt__ierr_0.csv" value((((VS("/V_OUT") - VAR("V_CM")) / VAR("rf")) - xval(((VS("/V_OUT") - VAR("V_CM")) / VAR("rf")))) 0)))
    errset(mtxDump("/home/mseminario2/vestarv/implementations/asic/castalia/analog/data/raw/px_hg1m_dc__tt__ierr_lsb.csv" ((((VS("/V_OUT") - VAR("V_CM")) / VAR("rf")) - xval(((VS("/V_OUT") - VAR("V_CM")) / VAR("rf")))) * VAR("rf") / 0.002441)))
    errset(mtxDump("/home/mseminario2/vestarv/implementations/asic/castalia/analog/data/raw/px_hg1m_dc__tt__ierr_lsb_max.csv" ymax(abs(clip((((((VS("/V_OUT") - VAR("V_CM")) / VAR("rf")) - xval(((VS("/V_OUT") - VAR("V_CM")) / VAR("rf")))) * VAR("rf")) / 0.002441) (0 - (1.155 / VAR("rf"))) (1.155 / VAR("rf")))))))
    errset(mtxDump("/home/mseminario2/vestarv/implementations/asic/castalia/analog/data/raw/px_hg1m_dc__tt__slope_err_0.csv" (value(deriv(((VS("/V_OUT") - VAR("V_CM")) / VAR("rf"))) 0) - 1)))
  )
)

;; ---- corner 2 (ff) / test px_hg1m_dc
when(isDir("/home/mseminario2/chips/castalia/simruns/tb_anatop_pixel_iacc_hg_1M_corners/castalia/tb_anatop_pixel/maestro/results/maestro/Ocean.0/2/ps_iacc_hg/psf")
  openResults("/home/mseminario2/chips/castalia/simruns/tb_anatop_pixel_iacc_hg_1M_corners/castalia/tb_anatop_pixel/maestro/results/maestro/Ocean.0/2/ps_iacc_hg/psf")
  when(member('dc results())
    selectResult('dc)
    mtxP = outfile("/home/mseminario2/vestarv/implementations/asic/castalia/analog/data/raw/px_hg1m_dc__ff.meta" "w")
    fprintf(mtxP "sweep %%L\n" car(errset(sweepNames())))
    close(mtxP)
    errset(mtxDump("/home/mseminario2/vestarv/implementations/asic/castalia/analog/data/raw/px_hg1m_dc__ff__ierr_0.csv" value((((VS("/V_OUT") - VAR("V_CM")) / VAR("rf")) - xval(((VS("/V_OUT") - VAR("V_CM")) / VAR("rf")))) 0)))
    errset(mtxDump("/home/mseminario2/vestarv/implementations/asic/castalia/analog/data/raw/px_hg1m_dc__ff__ierr_lsb.csv" ((((VS("/V_OUT") - VAR("V_CM")) / VAR("rf")) - xval(((VS("/V_OUT") - VAR("V_CM")) / VAR("rf")))) * VAR("rf") / 0.002441)))
    errset(mtxDump("/home/mseminario2/vestarv/implementations/asic/castalia/analog/data/raw/px_hg1m_dc__ff__ierr_lsb_max.csv" ymax(abs(clip((((((VS("/V_OUT") - VAR("V_CM")) / VAR("rf")) - xval(((VS("/V_OUT") - VAR("V_CM")) / VAR("rf")))) * VAR("rf")) / 0.002441) (0 - (1.155 / VAR("rf"))) (1.155 / VAR("rf")))))))
    errset(mtxDump("/home/mseminario2/vestarv/implementations/asic/castalia/analog/data/raw/px_hg1m_dc__ff__slope_err_0.csv" (value(deriv(((VS("/V_OUT") - VAR("V_CM")) / VAR("rf"))) 0) - 1)))
  )
)

;; ---- corner 3 (fs) / test px_hg1m_dc
when(isDir("/home/mseminario2/chips/castalia/simruns/tb_anatop_pixel_iacc_hg_1M_corners/castalia/tb_anatop_pixel/maestro/results/maestro/Ocean.0/3/ps_iacc_hg/psf")
  openResults("/home/mseminario2/chips/castalia/simruns/tb_anatop_pixel_iacc_hg_1M_corners/castalia/tb_anatop_pixel/maestro/results/maestro/Ocean.0/3/ps_iacc_hg/psf")
  when(member('dc results())
    selectResult('dc)
    mtxP = outfile("/home/mseminario2/vestarv/implementations/asic/castalia/analog/data/raw/px_hg1m_dc__fs.meta" "w")
    fprintf(mtxP "sweep %%L\n" car(errset(sweepNames())))
    close(mtxP)
    errset(mtxDump("/home/mseminario2/vestarv/implementations/asic/castalia/analog/data/raw/px_hg1m_dc__fs__ierr_0.csv" value((((VS("/V_OUT") - VAR("V_CM")) / VAR("rf")) - xval(((VS("/V_OUT") - VAR("V_CM")) / VAR("rf")))) 0)))
    errset(mtxDump("/home/mseminario2/vestarv/implementations/asic/castalia/analog/data/raw/px_hg1m_dc__fs__ierr_lsb.csv" ((((VS("/V_OUT") - VAR("V_CM")) / VAR("rf")) - xval(((VS("/V_OUT") - VAR("V_CM")) / VAR("rf")))) * VAR("rf") / 0.002441)))
    errset(mtxDump("/home/mseminario2/vestarv/implementations/asic/castalia/analog/data/raw/px_hg1m_dc__fs__ierr_lsb_max.csv" ymax(abs(clip((((((VS("/V_OUT") - VAR("V_CM")) / VAR("rf")) - xval(((VS("/V_OUT") - VAR("V_CM")) / VAR("rf")))) * VAR("rf")) / 0.002441) (0 - (1.155 / VAR("rf"))) (1.155 / VAR("rf")))))))
    errset(mtxDump("/home/mseminario2/vestarv/implementations/asic/castalia/analog/data/raw/px_hg1m_dc__fs__slope_err_0.csv" (value(deriv(((VS("/V_OUT") - VAR("V_CM")) / VAR("rf"))) 0) - 1)))
  )
)

;; ---- corner 4 (sf) / test px_hg1m_dc
when(isDir("/home/mseminario2/chips/castalia/simruns/tb_anatop_pixel_iacc_hg_1M_corners/castalia/tb_anatop_pixel/maestro/results/maestro/Ocean.0/4/ps_iacc_hg/psf")
  openResults("/home/mseminario2/chips/castalia/simruns/tb_anatop_pixel_iacc_hg_1M_corners/castalia/tb_anatop_pixel/maestro/results/maestro/Ocean.0/4/ps_iacc_hg/psf")
  when(member('dc results())
    selectResult('dc)
    mtxP = outfile("/home/mseminario2/vestarv/implementations/asic/castalia/analog/data/raw/px_hg1m_dc__sf.meta" "w")
    fprintf(mtxP "sweep %%L\n" car(errset(sweepNames())))
    close(mtxP)
    errset(mtxDump("/home/mseminario2/vestarv/implementations/asic/castalia/analog/data/raw/px_hg1m_dc__sf__ierr_0.csv" value((((VS("/V_OUT") - VAR("V_CM")) / VAR("rf")) - xval(((VS("/V_OUT") - VAR("V_CM")) / VAR("rf")))) 0)))
    errset(mtxDump("/home/mseminario2/vestarv/implementations/asic/castalia/analog/data/raw/px_hg1m_dc__sf__ierr_lsb.csv" ((((VS("/V_OUT") - VAR("V_CM")) / VAR("rf")) - xval(((VS("/V_OUT") - VAR("V_CM")) / VAR("rf")))) * VAR("rf") / 0.002441)))
    errset(mtxDump("/home/mseminario2/vestarv/implementations/asic/castalia/analog/data/raw/px_hg1m_dc__sf__ierr_lsb_max.csv" ymax(abs(clip((((((VS("/V_OUT") - VAR("V_CM")) / VAR("rf")) - xval(((VS("/V_OUT") - VAR("V_CM")) / VAR("rf")))) * VAR("rf")) / 0.002441) (0 - (1.155 / VAR("rf"))) (1.155 / VAR("rf")))))))
    errset(mtxDump("/home/mseminario2/vestarv/implementations/asic/castalia/analog/data/raw/px_hg1m_dc__sf__slope_err_0.csv" (value(deriv(((VS("/V_OUT") - VAR("V_CM")) / VAR("rf"))) 0) - 1)))
  )
)

;; ---- corner 5 (ss) / test px_hg1m_dc
when(isDir("/home/mseminario2/chips/castalia/simruns/tb_anatop_pixel_iacc_hg_1M_corners/castalia/tb_anatop_pixel/maestro/results/maestro/Ocean.0/5/ps_iacc_hg/psf")
  openResults("/home/mseminario2/chips/castalia/simruns/tb_anatop_pixel_iacc_hg_1M_corners/castalia/tb_anatop_pixel/maestro/results/maestro/Ocean.0/5/ps_iacc_hg/psf")
  when(member('dc results())
    selectResult('dc)
    mtxP = outfile("/home/mseminario2/vestarv/implementations/asic/castalia/analog/data/raw/px_hg1m_dc__ss.meta" "w")
    fprintf(mtxP "sweep %%L\n" car(errset(sweepNames())))
    close(mtxP)
    errset(mtxDump("/home/mseminario2/vestarv/implementations/asic/castalia/analog/data/raw/px_hg1m_dc__ss__ierr_0.csv" value((((VS("/V_OUT") - VAR("V_CM")) / VAR("rf")) - xval(((VS("/V_OUT") - VAR("V_CM")) / VAR("rf")))) 0)))
    errset(mtxDump("/home/mseminario2/vestarv/implementations/asic/castalia/analog/data/raw/px_hg1m_dc__ss__ierr_lsb.csv" ((((VS("/V_OUT") - VAR("V_CM")) / VAR("rf")) - xval(((VS("/V_OUT") - VAR("V_CM")) / VAR("rf")))) * VAR("rf") / 0.002441)))
    errset(mtxDump("/home/mseminario2/vestarv/implementations/asic/castalia/analog/data/raw/px_hg1m_dc__ss__ierr_lsb_max.csv" ymax(abs(clip((((((VS("/V_OUT") - VAR("V_CM")) / VAR("rf")) - xval(((VS("/V_OUT") - VAR("V_CM")) / VAR("rf")))) * VAR("rf")) / 0.002441) (0 - (1.155 / VAR("rf"))) (1.155 / VAR("rf")))))))
    errset(mtxDump("/home/mseminario2/vestarv/implementations/asic/castalia/analog/data/raw/px_hg1m_dc__ss__slope_err_0.csv" (value(deriv(((VS("/V_OUT") - VAR("V_CM")) / VAR("rf"))) 0) - 1)))
  )
)

printf("MTX_EXTRACT_DONE\n")
exit(0)
