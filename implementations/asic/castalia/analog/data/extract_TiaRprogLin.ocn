;; generated by maestro2tex -- do not edit
procedure(mtxDump(fname wv)
  let((xs ys n p)
    p = outfile(fname "w")
    cond(
      (null(wv) fprintf(p "#nil\n"))
      (drIsWaveform(wv)
        xs = drGetWaveformXVec(wv)
        ys = drGetWaveformYVec(wv)
        n = drVectorLength(xs)
        for(i 0 n-1
          fprintf(p "%.10g %.10g\n" drGetElem(xs i) drGetElem(ys i)))
      )
      (t fprintf(p "#scalar %.10g\n" float(wv)))
    )
    close(p)
    t))

;; ---- corner 1 (typ) / test rp_lin
when(isDir("/home/mseminario2/chips/castalia/simruns/tb_anatop_tia_rprog_lin_n0/castalia/tb_anatop_tia_rprog/maestro/results/maestro/Ocean.0/1/rp_lin/psf")
  openResults("/home/mseminario2/chips/castalia/simruns/tb_anatop_tia_rprog_lin_n0/castalia/tb_anatop_tia_rprog/maestro/results/maestro/Ocean.0/1/rp_lin/psf")
  when(member('dc results())
    selectResult('dc)
    mtxP = outfile("/home/mseminario2/vestarv/implementations/asic/castalia/analog/data/raw/rp_lin__typ.meta" "w")
    fprintf(mtxP "sweep %%L\n" car(errset(sweepNames())))
    close(mtxP)
    errset(mtxDump("/home/mseminario2/vestarv/implementations/asic/castalia/analog/data/raw/rp_lin__typ__r_chord.csv" ((((value((VS("/A_T") - VS("/B_T")) 0.9) - value((VS("/A_T") - VS("/B_T")) -0.9)) / 1.8) / (0.8 / 18000.0)) / 1000.0)))
    errset(mtxDump("/home/mseminario2/vestarv/implementations/asic/castalia/analog/data/raw/rp_lin__typ__rmod_pct.csv" (100.0 * (ymax((VS("/A_T") - VS("/B_T")) / (xval(VS("/A_T")) * (0.8 / 18000.0))) - ymin((VS("/A_T") - VS("/B_T")) / (xval(VS("/A_T")) * (0.8 / 18000.0)))) / value((VS("/A_T") - VS("/B_T")) / (xval(VS("/A_T")) * (0.8 / 18000.0)) 0.9))))
    errset(mtxDump("/home/mseminario2/vestarv/implementations/asic/castalia/analog/data/raw/rp_lin__typ__verr_lsb.csv" (((VS("/A_T") - VS("/B_T")) - (((value((VS("/A_T") - VS("/B_T")) 0.9) + value((VS("/A_T") - VS("/B_T")) -0.9)) / 2.0) + (((value((VS("/A_T") - VS("/B_T")) 0.9) - value((VS("/A_T") - VS("/B_T")) -0.9)) / 1.8) * xval(VS("/A_T"))))) / 1.592e-3)))
    errset(mtxDump("/home/mseminario2/vestarv/implementations/asic/castalia/analog/data/raw/rp_lin__typ__verr_max_lsb.csv" (ymax(abs(((VS("/A_T") - VS("/B_T")) - (((value((VS("/A_T") - VS("/B_T")) 0.9) + value((VS("/A_T") - VS("/B_T")) -0.9)) / 2.0) + (((value((VS("/A_T") - VS("/B_T")) 0.9) - value((VS("/A_T") - VS("/B_T")) -0.9)) / 1.8) * xval(VS("/A_T"))))))) / 1.592e-3)))
    errset(mtxDump("/home/mseminario2/vestarv/implementations/asic/castalia/analog/data/raw/rp_lin__typ__verr_max_mv.csv" (ymax(abs(((VS("/A_T") - VS("/B_T")) - (((value((VS("/A_T") - VS("/B_T")) 0.9) + value((VS("/A_T") - VS("/B_T")) -0.9)) / 2.0) + (((value((VS("/A_T") - VS("/B_T")) 0.9) - value((VS("/A_T") - VS("/B_T")) -0.9)) / 1.8) * xval(VS("/A_T"))))))) * 1000.0)))
  )
)

printf("MTX_EXTRACT_DONE\n")
exit(0)
