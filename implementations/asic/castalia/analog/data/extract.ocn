;; generated by maestro2tex -- do not edit
procedure(mtxDump(fname wv)
  let((xs ys n p)
    p = outfile(fname "w")
    cond(
      (null(wv) fprintf(p "#nil\n"))
      (drIsWaveform(wv)
        xs = drGetWaveformXVec(wv)
        ys = drGetWaveformYVec(wv)
        n = drVectorLength(xs)
        for(i 0 n-1
          fprintf(p "%.10g %.10g\n" drGetElem(xs i) drGetElem(ys i)))
      )
      (t fprintf(p "#scalar %.10g\n" float(wv)))
    )
    close(p)
    t))

;; ---- corner 1 (tt) / test BiasStartupTB
when(isDir("/home/mseminario2/chips/castalia/ic/.simulation/castalia/BiasGenCascWideSwing_tb/maestro/results/maestro/Interactive.32/1/BiasStartupTB/psf")
  openResults("/home/mseminario2/chips/castalia/ic/.simulation/castalia/BiasGenCascWideSwing_tb/maestro/results/maestro/Interactive.32/1/BiasStartupTB/psf")
  when(member('tran results())
    selectResult('tran)
    mtxP = outfile("/home/mseminario2/vestarv/implementations/asic/castalia/analog/data/raw/BiasStartupTB__tt.meta" "w")
    fprintf(mtxP "sweep %%L\n" car(errset(sweepNames())))
    close(mtxP)
    errset(mtxDump("/home/mseminario2/vestarv/implementations/asic/castalia/analog/data/raw/BiasStartupTB__tt__idd.csv" abs(i("/V0/PLUS"))))
    errset(mtxDump("/home/mseminario2/vestarv/implementations/asic/castalia/analog/data/raw/BiasStartupTB__tt__vbnc.csv" v("/V_BNC")))
    errset(mtxDump("/home/mseminario2/vestarv/implementations/asic/castalia/analog/data/raw/BiasStartupTB__tt__vbnm.csv" v("/V_BNM")))
    errset(mtxDump("/home/mseminario2/vestarv/implementations/asic/castalia/analog/data/raw/BiasStartupTB__tt__vbpc.csv" v("/V_BPC")))
    errset(mtxDump("/home/mseminario2/vestarv/implementations/asic/castalia/analog/data/raw/BiasStartupTB__tt__vbpm.csv" v("/V_BPM")))
    errset(mtxDump("/home/mseminario2/vestarv/implementations/asic/castalia/analog/data/raw/BiasStartupTB__tt__vdd.csv" v("/vdd!")))
    errset(mtxDump("/home/mseminario2/vestarv/implementations/asic/castalia/analog/data/raw/BiasStartupTB__tt__vsgpc.csv" (v("/vdd!") - v("/V_BPC"))))
    errset(mtxDump("/home/mseminario2/vestarv/implementations/asic/castalia/analog/data/raw/BiasStartupTB__tt__vsgpm.csv" (v("/vdd!") - v("/V_BPM"))))
    errset(mtxDump("/home/mseminario2/vestarv/implementations/asic/castalia/analog/data/raw/BiasStartupTB__tt__vsu.csv" v("/BIASGEN/V_SU")))
  )
)

;; ---- corner 1 (tt) / test DCOpTB
when(isDir("/home/mseminario2/chips/castalia/ic/.simulation/castalia/BiasGenCascWideSwing_tb/maestro/results/maestro/Interactive.32/1/DCOpTB/psf")
  openResults("/home/mseminario2/chips/castalia/ic/.simulation/castalia/BiasGenCascWideSwing_tb/maestro/results/maestro/Interactive.32/1/DCOpTB/psf")
  when(member('dcOp results())
    selectResult('dcOp)
    mtxP = outfile("/home/mseminario2/vestarv/implementations/asic/castalia/analog/data/raw/DCOpTB__tt.meta" "w")
    fprintf(mtxP "sweep %%L\n" car(errset(sweepNames())))
    close(mtxP)
    errset(mtxDump("/home/mseminario2/vestarv/implementations/asic/castalia/analog/data/raw/DCOpTB__tt__idd.csv" abs(i("/POWER/SRC_VDD25/PLUS"))))
    errset(mtxDump("/home/mseminario2/vestarv/implementations/asic/castalia/analog/data/raw/DCOpTB__tt__vbnc.csv" v("/V_BNC")))
    errset(mtxDump("/home/mseminario2/vestarv/implementations/asic/castalia/analog/data/raw/DCOpTB__tt__vbnm.csv" v("/V_BNM")))
    errset(mtxDump("/home/mseminario2/vestarv/implementations/asic/castalia/analog/data/raw/DCOpTB__tt__vbpc.csv" v("/V_BPC")))
    errset(mtxDump("/home/mseminario2/vestarv/implementations/asic/castalia/analog/data/raw/DCOpTB__tt__vbpm.csv" v("/V_BPM")))
    errset(mtxDump("/home/mseminario2/vestarv/implementations/asic/castalia/analog/data/raw/DCOpTB__tt__vsgpc.csv" (v("/vdd!") - v("/V_BPC"))))
    errset(mtxDump("/home/mseminario2/vestarv/implementations/asic/castalia/analog/data/raw/DCOpTB__tt__vsgpm.csv" (v("/vdd!") - v("/V_BPM"))))
  )
)

;; ---- corner 1 (tt) / test bg_adj
when(isDir("/home/mseminario2/chips/castalia/ic/.simulation/castalia/BiasGenCascWideSwing_tb/maestro/results/maestro/Interactive.32/1/bg_adj/psf")
  openResults("/home/mseminario2/chips/castalia/ic/.simulation/castalia/BiasGenCascWideSwing_tb/maestro/results/maestro/Interactive.32/1/bg_adj/psf")
  when(member('dc results())
    selectResult('dc)
    mtxP = outfile("/home/mseminario2/vestarv/implementations/asic/castalia/analog/data/raw/bg_adj__tt.meta" "w")
    fprintf(mtxP "sweep %%L\n" car(errset(sweepNames())))
    close(mtxP)
    errset(mtxDump("/home/mseminario2/vestarv/implementations/asic/castalia/analog/data/raw/bg_adj__tt__idd.csv" abs(i("/POWER/SRC_VDD25/PLUS"))))
    errset(mtxDump("/home/mseminario2/vestarv/implementations/asic/castalia/analog/data/raw/bg_adj__tt__vbnc.csv" v("/V_BNC")))
    errset(mtxDump("/home/mseminario2/vestarv/implementations/asic/castalia/analog/data/raw/bg_adj__tt__vbnm.csv" v("/V_BNM")))
    errset(mtxDump("/home/mseminario2/vestarv/implementations/asic/castalia/analog/data/raw/bg_adj__tt__vbpc.csv" v("/V_BPC")))
    errset(mtxDump("/home/mseminario2/vestarv/implementations/asic/castalia/analog/data/raw/bg_adj__tt__vbpm.csv" v("/V_BPM")))
    errset(mtxDump("/home/mseminario2/vestarv/implementations/asic/castalia/analog/data/raw/bg_adj__tt__vsgpc.csv" (v("/vdd!") - v("/V_BPC"))))
    errset(mtxDump("/home/mseminario2/vestarv/implementations/asic/castalia/analog/data/raw/bg_adj__tt__vsgpm.csv" (v("/vdd!") - v("/V_BPM"))))
  )
)

;; ---- corner 1 (tt) / test bg_temp
when(isDir("/home/mseminario2/chips/castalia/ic/.simulation/castalia/BiasGenCascWideSwing_tb/maestro/results/maestro/Interactive.32/1/bg_temp/psf")
  openResults("/home/mseminario2/chips/castalia/ic/.simulation/castalia/BiasGenCascWideSwing_tb/maestro/results/maestro/Interactive.32/1/bg_temp/psf")
  when(member('dc results())
    selectResult('dc)
    mtxP = outfile("/home/mseminario2/vestarv/implementations/asic/castalia/analog/data/raw/bg_temp__tt.meta" "w")
    fprintf(mtxP "sweep %%L\n" car(errset(sweepNames())))
    close(mtxP)
    errset(mtxDump("/home/mseminario2/vestarv/implementations/asic/castalia/analog/data/raw/bg_temp__tt__idd.csv" abs(i("/POWER/SRC_VDD25/PLUS"))))
    errset(mtxDump("/home/mseminario2/vestarv/implementations/asic/castalia/analog/data/raw/bg_temp__tt__vbnc.csv" v("/V_BNC")))
    errset(mtxDump("/home/mseminario2/vestarv/implementations/asic/castalia/analog/data/raw/bg_temp__tt__vbnm.csv" v("/V_BNM")))
    errset(mtxDump("/home/mseminario2/vestarv/implementations/asic/castalia/analog/data/raw/bg_temp__tt__vbpc.csv" v("/V_BPC")))
    errset(mtxDump("/home/mseminario2/vestarv/implementations/asic/castalia/analog/data/raw/bg_temp__tt__vbpm.csv" v("/V_BPM")))
    errset(mtxDump("/home/mseminario2/vestarv/implementations/asic/castalia/analog/data/raw/bg_temp__tt__vsgpc.csv" (v("/vdd!") - v("/V_BPC"))))
    errset(mtxDump("/home/mseminario2/vestarv/implementations/asic/castalia/analog/data/raw/bg_temp__tt__vsgpm.csv" (v("/vdd!") - v("/V_BPM"))))
  )
)

;; ---- corner 1 (tt) / test bg_vdd
when(isDir("/home/mseminario2/chips/castalia/ic/.simulation/castalia/BiasGenCascWideSwing_tb/maestro/results/maestro/Interactive.32/1/bg_vdd/psf")
  openResults("/home/mseminario2/chips/castalia/ic/.simulation/castalia/BiasGenCascWideSwing_tb/maestro/results/maestro/Interactive.32/1/bg_vdd/psf")
  when(member('dc results())
    selectResult('dc)
    mtxP = outfile("/home/mseminario2/vestarv/implementations/asic/castalia/analog/data/raw/bg_vdd__tt.meta" "w")
    fprintf(mtxP "sweep %%L\n" car(errset(sweepNames())))
    close(mtxP)
    errset(mtxDump("/home/mseminario2/vestarv/implementations/asic/castalia/analog/data/raw/bg_vdd__tt__idd.csv" abs(i("/POWER/SRC_VDD25/PLUS"))))
    errset(mtxDump("/home/mseminario2/vestarv/implementations/asic/castalia/analog/data/raw/bg_vdd__tt__vbnc.csv" v("/V_BNC")))
    errset(mtxDump("/home/mseminario2/vestarv/implementations/asic/castalia/analog/data/raw/bg_vdd__tt__vbnm.csv" v("/V_BNM")))
    errset(mtxDump("/home/mseminario2/vestarv/implementations/asic/castalia/analog/data/raw/bg_vdd__tt__vbpc.csv" v("/V_BPC")))
    errset(mtxDump("/home/mseminario2/vestarv/implementations/asic/castalia/analog/data/raw/bg_vdd__tt__vbpm.csv" v("/V_BPM")))
    errset(mtxDump("/home/mseminario2/vestarv/implementations/asic/castalia/analog/data/raw/bg_vdd__tt__vsgpc.csv" (v("/vdd!") - v("/V_BPC"))))
    errset(mtxDump("/home/mseminario2/vestarv/implementations/asic/castalia/analog/data/raw/bg_vdd__tt__vsgpm.csv" (v("/vdd!") - v("/V_BPM"))))
  )
)

;; ---- corner 2 (ff) / test BiasStartupTB
when(isDir("/home/mseminario2/chips/castalia/ic/.simulation/castalia/BiasGenCascWideSwing_tb/maestro/results/maestro/Interactive.32/2/BiasStartupTB/psf")
  openResults("/home/mseminario2/chips/castalia/ic/.simulation/castalia/BiasGenCascWideSwing_tb/maestro/results/maestro/Interactive.32/2/BiasStartupTB/psf")
  when(member('tran results())
    selectResult('tran)
    mtxP = outfile("/home/mseminario2/vestarv/implementations/asic/castalia/analog/data/raw/BiasStartupTB__ff.meta" "w")
    fprintf(mtxP "sweep %%L\n" car(errset(sweepNames())))
    close(mtxP)
    errset(mtxDump("/home/mseminario2/vestarv/implementations/asic/castalia/analog/data/raw/BiasStartupTB__ff__idd.csv" abs(i("/V0/PLUS"))))
    errset(mtxDump("/home/mseminario2/vestarv/implementations/asic/castalia/analog/data/raw/BiasStartupTB__ff__vbnc.csv" v("/V_BNC")))
    errset(mtxDump("/home/mseminario2/vestarv/implementations/asic/castalia/analog/data/raw/BiasStartupTB__ff__vbnm.csv" v("/V_BNM")))
    errset(mtxDump("/home/mseminario2/vestarv/implementations/asic/castalia/analog/data/raw/BiasStartupTB__ff__vbpc.csv" v("/V_BPC")))
    errset(mtxDump("/home/mseminario2/vestarv/implementations/asic/castalia/analog/data/raw/BiasStartupTB__ff__vbpm.csv" v("/V_BPM")))
    errset(mtxDump("/home/mseminario2/vestarv/implementations/asic/castalia/analog/data/raw/BiasStartupTB__ff__vdd.csv" v("/vdd!")))
    errset(mtxDump("/home/mseminario2/vestarv/implementations/asic/castalia/analog/data/raw/BiasStartupTB__ff__vsgpc.csv" (v("/vdd!") - v("/V_BPC"))))
    errset(mtxDump("/home/mseminario2/vestarv/implementations/asic/castalia/analog/data/raw/BiasStartupTB__ff__vsgpm.csv" (v("/vdd!") - v("/V_BPM"))))
    errset(mtxDump("/home/mseminario2/vestarv/implementations/asic/castalia/analog/data/raw/BiasStartupTB__ff__vsu.csv" v("/BIASGEN/V_SU")))
  )
)

;; ---- corner 2 (ff) / test DCOpTB
when(isDir("/home/mseminario2/chips/castalia/ic/.simulation/castalia/BiasGenCascWideSwing_tb/maestro/results/maestro/Interactive.32/2/DCOpTB/psf")
  openResults("/home/mseminario2/chips/castalia/ic/.simulation/castalia/BiasGenCascWideSwing_tb/maestro/results/maestro/Interactive.32/2/DCOpTB/psf")
  when(member('dcOp results())
    selectResult('dcOp)
    mtxP = outfile("/home/mseminario2/vestarv/implementations/asic/castalia/analog/data/raw/DCOpTB__ff.meta" "w")
    fprintf(mtxP "sweep %%L\n" car(errset(sweepNames())))
    close(mtxP)
    errset(mtxDump("/home/mseminario2/vestarv/implementations/asic/castalia/analog/data/raw/DCOpTB__ff__idd.csv" abs(i("/POWER/SRC_VDD25/PLUS"))))
    errset(mtxDump("/home/mseminario2/vestarv/implementations/asic/castalia/analog/data/raw/DCOpTB__ff__vbnc.csv" v("/V_BNC")))
    errset(mtxDump("/home/mseminario2/vestarv/implementations/asic/castalia/analog/data/raw/DCOpTB__ff__vbnm.csv" v("/V_BNM")))
    errset(mtxDump("/home/mseminario2/vestarv/implementations/asic/castalia/analog/data/raw/DCOpTB__ff__vbpc.csv" v("/V_BPC")))
    errset(mtxDump("/home/mseminario2/vestarv/implementations/asic/castalia/analog/data/raw/DCOpTB__ff__vbpm.csv" v("/V_BPM")))
    errset(mtxDump("/home/mseminario2/vestarv/implementations/asic/castalia/analog/data/raw/DCOpTB__ff__vsgpc.csv" (v("/vdd!") - v("/V_BPC"))))
    errset(mtxDump("/home/mseminario2/vestarv/implementations/asic/castalia/analog/data/raw/DCOpTB__ff__vsgpm.csv" (v("/vdd!") - v("/V_BPM"))))
  )
)

;; ---- corner 2 (ff) / test bg_adj
when(isDir("/home/mseminario2/chips/castalia/ic/.simulation/castalia/BiasGenCascWideSwing_tb/maestro/results/maestro/Interactive.32/2/bg_adj/psf")
  openResults("/home/mseminario2/chips/castalia/ic/.simulation/castalia/BiasGenCascWideSwing_tb/maestro/results/maestro/Interactive.32/2/bg_adj/psf")
  when(member('dc results())
    selectResult('dc)
    mtxP = outfile("/home/mseminario2/vestarv/implementations/asic/castalia/analog/data/raw/bg_adj__ff.meta" "w")
    fprintf(mtxP "sweep %%L\n" car(errset(sweepNames())))
    close(mtxP)
    errset(mtxDump("/home/mseminario2/vestarv/implementations/asic/castalia/analog/data/raw/bg_adj__ff__idd.csv" abs(i("/POWER/SRC_VDD25/PLUS"))))
    errset(mtxDump("/home/mseminario2/vestarv/implementations/asic/castalia/analog/data/raw/bg_adj__ff__vbnc.csv" v("/V_BNC")))
    errset(mtxDump("/home/mseminario2/vestarv/implementations/asic/castalia/analog/data/raw/bg_adj__ff__vbnm.csv" v("/V_BNM")))
    errset(mtxDump("/home/mseminario2/vestarv/implementations/asic/castalia/analog/data/raw/bg_adj__ff__vbpc.csv" v("/V_BPC")))
    errset(mtxDump("/home/mseminario2/vestarv/implementations/asic/castalia/analog/data/raw/bg_adj__ff__vbpm.csv" v("/V_BPM")))
    errset(mtxDump("/home/mseminario2/vestarv/implementations/asic/castalia/analog/data/raw/bg_adj__ff__vsgpc.csv" (v("/vdd!") - v("/V_BPC"))))
    errset(mtxDump("/home/mseminario2/vestarv/implementations/asic/castalia/analog/data/raw/bg_adj__ff__vsgpm.csv" (v("/vdd!") - v("/V_BPM"))))
  )
)

;; ---- corner 2 (ff) / test bg_temp
when(isDir("/home/mseminario2/chips/castalia/ic/.simulation/castalia/BiasGenCascWideSwing_tb/maestro/results/maestro/Interactive.32/2/bg_temp/psf")
  openResults("/home/mseminario2/chips/castalia/ic/.simulation/castalia/BiasGenCascWideSwing_tb/maestro/results/maestro/Interactive.32/2/bg_temp/psf")
  when(member('dc results())
    selectResult('dc)
    mtxP = outfile("/home/mseminario2/vestarv/implementations/asic/castalia/analog/data/raw/bg_temp__ff.meta" "w")
    fprintf(mtxP "sweep %%L\n" car(errset(sweepNames())))
    close(mtxP)
    errset(mtxDump("/home/mseminario2/vestarv/implementations/asic/castalia/analog/data/raw/bg_temp__ff__idd.csv" abs(i("/POWER/SRC_VDD25/PLUS"))))
    errset(mtxDump("/home/mseminario2/vestarv/implementations/asic/castalia/analog/data/raw/bg_temp__ff__vbnc.csv" v("/V_BNC")))
    errset(mtxDump("/home/mseminario2/vestarv/implementations/asic/castalia/analog/data/raw/bg_temp__ff__vbnm.csv" v("/V_BNM")))
    errset(mtxDump("/home/mseminario2/vestarv/implementations/asic/castalia/analog/data/raw/bg_temp__ff__vbpc.csv" v("/V_BPC")))
    errset(mtxDump("/home/mseminario2/vestarv/implementations/asic/castalia/analog/data/raw/bg_temp__ff__vbpm.csv" v("/V_BPM")))
    errset(mtxDump("/home/mseminario2/vestarv/implementations/asic/castalia/analog/data/raw/bg_temp__ff__vsgpc.csv" (v("/vdd!") - v("/V_BPC"))))
    errset(mtxDump("/home/mseminario2/vestarv/implementations/asic/castalia/analog/data/raw/bg_temp__ff__vsgpm.csv" (v("/vdd!") - v("/V_BPM"))))
  )
)

;; ---- corner 2 (ff) / test bg_vdd
when(isDir("/home/mseminario2/chips/castalia/ic/.simulation/castalia/BiasGenCascWideSwing_tb/maestro/results/maestro/Interactive.32/2/bg_vdd/psf")
  openResults("/home/mseminario2/chips/castalia/ic/.simulation/castalia/BiasGenCascWideSwing_tb/maestro/results/maestro/Interactive.32/2/bg_vdd/psf")
  when(member('dc results())
    selectResult('dc)
    mtxP = outfile("/home/mseminario2/vestarv/implementations/asic/castalia/analog/data/raw/bg_vdd__ff.meta" "w")
    fprintf(mtxP "sweep %%L\n" car(errset(sweepNames())))
    close(mtxP)
    errset(mtxDump("/home/mseminario2/vestarv/implementations/asic/castalia/analog/data/raw/bg_vdd__ff__idd.csv" abs(i("/POWER/SRC_VDD25/PLUS"))))
    errset(mtxDump("/home/mseminario2/vestarv/implementations/asic/castalia/analog/data/raw/bg_vdd__ff__vbnc.csv" v("/V_BNC")))
    errset(mtxDump("/home/mseminario2/vestarv/implementations/asic/castalia/analog/data/raw/bg_vdd__ff__vbnm.csv" v("/V_BNM")))
    errset(mtxDump("/home/mseminario2/vestarv/implementations/asic/castalia/analog/data/raw/bg_vdd__ff__vbpc.csv" v("/V_BPC")))
    errset(mtxDump("/home/mseminario2/vestarv/implementations/asic/castalia/analog/data/raw/bg_vdd__ff__vbpm.csv" v("/V_BPM")))
    errset(mtxDump("/home/mseminario2/vestarv/implementations/asic/castalia/analog/data/raw/bg_vdd__ff__vsgpc.csv" (v("/vdd!") - v("/V_BPC"))))
    errset(mtxDump("/home/mseminario2/vestarv/implementations/asic/castalia/analog/data/raw/bg_vdd__ff__vsgpm.csv" (v("/vdd!") - v("/V_BPM"))))
  )
)

;; ---- corner 3 (fs) / test BiasStartupTB
when(isDir("/home/mseminario2/chips/castalia/ic/.simulation/castalia/BiasGenCascWideSwing_tb/maestro/results/maestro/Interactive.32/3/BiasStartupTB/psf")
  openResults("/home/mseminario2/chips/castalia/ic/.simulation/castalia/BiasGenCascWideSwing_tb/maestro/results/maestro/Interactive.32/3/BiasStartupTB/psf")
  when(member('tran results())
    selectResult('tran)
    mtxP = outfile("/home/mseminario2/vestarv/implementations/asic/castalia/analog/data/raw/BiasStartupTB__fs.meta" "w")
    fprintf(mtxP "sweep %%L\n" car(errset(sweepNames())))
    close(mtxP)
    errset(mtxDump("/home/mseminario2/vestarv/implementations/asic/castalia/analog/data/raw/BiasStartupTB__fs__idd.csv" abs(i("/V0/PLUS"))))
    errset(mtxDump("/home/mseminario2/vestarv/implementations/asic/castalia/analog/data/raw/BiasStartupTB__fs__vbnc.csv" v("/V_BNC")))
    errset(mtxDump("/home/mseminario2/vestarv/implementations/asic/castalia/analog/data/raw/BiasStartupTB__fs__vbnm.csv" v("/V_BNM")))
    errset(mtxDump("/home/mseminario2/vestarv/implementations/asic/castalia/analog/data/raw/BiasStartupTB__fs__vbpc.csv" v("/V_BPC")))
    errset(mtxDump("/home/mseminario2/vestarv/implementations/asic/castalia/analog/data/raw/BiasStartupTB__fs__vbpm.csv" v("/V_BPM")))
    errset(mtxDump("/home/mseminario2/vestarv/implementations/asic/castalia/analog/data/raw/BiasStartupTB__fs__vdd.csv" v("/vdd!")))
    errset(mtxDump("/home/mseminario2/vestarv/implementations/asic/castalia/analog/data/raw/BiasStartupTB__fs__vsgpc.csv" (v("/vdd!") - v("/V_BPC"))))
    errset(mtxDump("/home/mseminario2/vestarv/implementations/asic/castalia/analog/data/raw/BiasStartupTB__fs__vsgpm.csv" (v("/vdd!") - v("/V_BPM"))))
    errset(mtxDump("/home/mseminario2/vestarv/implementations/asic/castalia/analog/data/raw/BiasStartupTB__fs__vsu.csv" v("/BIASGEN/V_SU")))
  )
)

;; ---- corner 3 (fs) / test DCOpTB
when(isDir("/home/mseminario2/chips/castalia/ic/.simulation/castalia/BiasGenCascWideSwing_tb/maestro/results/maestro/Interactive.32/3/DCOpTB/psf")
  openResults("/home/mseminario2/chips/castalia/ic/.simulation/castalia/BiasGenCascWideSwing_tb/maestro/results/maestro/Interactive.32/3/DCOpTB/psf")
  when(member('dcOp results())
    selectResult('dcOp)
    mtxP = outfile("/home/mseminario2/vestarv/implementations/asic/castalia/analog/data/raw/DCOpTB__fs.meta" "w")
    fprintf(mtxP "sweep %%L\n" car(errset(sweepNames())))
    close(mtxP)
    errset(mtxDump("/home/mseminario2/vestarv/implementations/asic/castalia/analog/data/raw/DCOpTB__fs__idd.csv" abs(i("/POWER/SRC_VDD25/PLUS"))))
    errset(mtxDump("/home/mseminario2/vestarv/implementations/asic/castalia/analog/data/raw/DCOpTB__fs__vbnc.csv" v("/V_BNC")))
    errset(mtxDump("/home/mseminario2/vestarv/implementations/asic/castalia/analog/data/raw/DCOpTB__fs__vbnm.csv" v("/V_BNM")))
    errset(mtxDump("/home/mseminario2/vestarv/implementations/asic/castalia/analog/data/raw/DCOpTB__fs__vbpc.csv" v("/V_BPC")))
    errset(mtxDump("/home/mseminario2/vestarv/implementations/asic/castalia/analog/data/raw/DCOpTB__fs__vbpm.csv" v("/V_BPM")))
    errset(mtxDump("/home/mseminario2/vestarv/implementations/asic/castalia/analog/data/raw/DCOpTB__fs__vsgpc.csv" (v("/vdd!") - v("/V_BPC"))))
    errset(mtxDump("/home/mseminario2/vestarv/implementations/asic/castalia/analog/data/raw/DCOpTB__fs__vsgpm.csv" (v("/vdd!") - v("/V_BPM"))))
  )
)

;; ---- corner 3 (fs) / test bg_adj
when(isDir("/home/mseminario2/chips/castalia/ic/.simulation/castalia/BiasGenCascWideSwing_tb/maestro/results/maestro/Interactive.32/3/bg_adj/psf")
  openResults("/home/mseminario2/chips/castalia/ic/.simulation/castalia/BiasGenCascWideSwing_tb/maestro/results/maestro/Interactive.32/3/bg_adj/psf")
  when(member('dc results())
    selectResult('dc)
    mtxP = outfile("/home/mseminario2/vestarv/implementations/asic/castalia/analog/data/raw/bg_adj__fs.meta" "w")
    fprintf(mtxP "sweep %%L\n" car(errset(sweepNames())))
    close(mtxP)
    errset(mtxDump("/home/mseminario2/vestarv/implementations/asic/castalia/analog/data/raw/bg_adj__fs__idd.csv" abs(i("/POWER/SRC_VDD25/PLUS"))))
    errset(mtxDump("/home/mseminario2/vestarv/implementations/asic/castalia/analog/data/raw/bg_adj__fs__vbnc.csv" v("/V_BNC")))
    errset(mtxDump("/home/mseminario2/vestarv/implementations/asic/castalia/analog/data/raw/bg_adj__fs__vbnm.csv" v("/V_BNM")))
    errset(mtxDump("/home/mseminario2/vestarv/implementations/asic/castalia/analog/data/raw/bg_adj__fs__vbpc.csv" v("/V_BPC")))
    errset(mtxDump("/home/mseminario2/vestarv/implementations/asic/castalia/analog/data/raw/bg_adj__fs__vbpm.csv" v("/V_BPM")))
    errset(mtxDump("/home/mseminario2/vestarv/implementations/asic/castalia/analog/data/raw/bg_adj__fs__vsgpc.csv" (v("/vdd!") - v("/V_BPC"))))
    errset(mtxDump("/home/mseminario2/vestarv/implementations/asic/castalia/analog/data/raw/bg_adj__fs__vsgpm.csv" (v("/vdd!") - v("/V_BPM"))))
  )
)

;; ---- corner 3 (fs) / test bg_temp
when(isDir("/home/mseminario2/chips/castalia/ic/.simulation/castalia/BiasGenCascWideSwing_tb/maestro/results/maestro/Interactive.32/3/bg_temp/psf")
  openResults("/home/mseminario2/chips/castalia/ic/.simulation/castalia/BiasGenCascWideSwing_tb/maestro/results/maestro/Interactive.32/3/bg_temp/psf")
  when(member('dc results())
    selectResult('dc)
    mtxP = outfile("/home/mseminario2/vestarv/implementations/asic/castalia/analog/data/raw/bg_temp__fs.meta" "w")
    fprintf(mtxP "sweep %%L\n" car(errset(sweepNames())))
    close(mtxP)
    errset(mtxDump("/home/mseminario2/vestarv/implementations/asic/castalia/analog/data/raw/bg_temp__fs__idd.csv" abs(i("/POWER/SRC_VDD25/PLUS"))))
    errset(mtxDump("/home/mseminario2/vestarv/implementations/asic/castalia/analog/data/raw/bg_temp__fs__vbnc.csv" v("/V_BNC")))
    errset(mtxDump("/home/mseminario2/vestarv/implementations/asic/castalia/analog/data/raw/bg_temp__fs__vbnm.csv" v("/V_BNM")))
    errset(mtxDump("/home/mseminario2/vestarv/implementations/asic/castalia/analog/data/raw/bg_temp__fs__vbpc.csv" v("/V_BPC")))
    errset(mtxDump("/home/mseminario2/vestarv/implementations/asic/castalia/analog/data/raw/bg_temp__fs__vbpm.csv" v("/V_BPM")))
    errset(mtxDump("/home/mseminario2/vestarv/implementations/asic/castalia/analog/data/raw/bg_temp__fs__vsgpc.csv" (v("/vdd!") - v("/V_BPC"))))
    errset(mtxDump("/home/mseminario2/vestarv/implementations/asic/castalia/analog/data/raw/bg_temp__fs__vsgpm.csv" (v("/vdd!") - v("/V_BPM"))))
  )
)

;; ---- corner 3 (fs) / test bg_vdd
when(isDir("/home/mseminario2/chips/castalia/ic/.simulation/castalia/BiasGenCascWideSwing_tb/maestro/results/maestro/Interactive.32/3/bg_vdd/psf")
  openResults("/home/mseminario2/chips/castalia/ic/.simulation/castalia/BiasGenCascWideSwing_tb/maestro/results/maestro/Interactive.32/3/bg_vdd/psf")
  when(member('dc results())
    selectResult('dc)
    mtxP = outfile("/home/mseminario2/vestarv/implementations/asic/castalia/analog/data/raw/bg_vdd__fs.meta" "w")
    fprintf(mtxP "sweep %%L\n" car(errset(sweepNames())))
    close(mtxP)
    errset(mtxDump("/home/mseminario2/vestarv/implementations/asic/castalia/analog/data/raw/bg_vdd__fs__idd.csv" abs(i("/POWER/SRC_VDD25/PLUS"))))
    errset(mtxDump("/home/mseminario2/vestarv/implementations/asic/castalia/analog/data/raw/bg_vdd__fs__vbnc.csv" v("/V_BNC")))
    errset(mtxDump("/home/mseminario2/vestarv/implementations/asic/castalia/analog/data/raw/bg_vdd__fs__vbnm.csv" v("/V_BNM")))
    errset(mtxDump("/home/mseminario2/vestarv/implementations/asic/castalia/analog/data/raw/bg_vdd__fs__vbpc.csv" v("/V_BPC")))
    errset(mtxDump("/home/mseminario2/vestarv/implementations/asic/castalia/analog/data/raw/bg_vdd__fs__vbpm.csv" v("/V_BPM")))
    errset(mtxDump("/home/mseminario2/vestarv/implementations/asic/castalia/analog/data/raw/bg_vdd__fs__vsgpc.csv" (v("/vdd!") - v("/V_BPC"))))
    errset(mtxDump("/home/mseminario2/vestarv/implementations/asic/castalia/analog/data/raw/bg_vdd__fs__vsgpm.csv" (v("/vdd!") - v("/V_BPM"))))
  )
)

;; ---- corner 4 (sf) / test BiasStartupTB
when(isDir("/home/mseminario2/chips/castalia/ic/.simulation/castalia/BiasGenCascWideSwing_tb/maestro/results/maestro/Interactive.32/4/BiasStartupTB/psf")
  openResults("/home/mseminario2/chips/castalia/ic/.simulation/castalia/BiasGenCascWideSwing_tb/maestro/results/maestro/Interactive.32/4/BiasStartupTB/psf")
  when(member('tran results())
    selectResult('tran)
    mtxP = outfile("/home/mseminario2/vestarv/implementations/asic/castalia/analog/data/raw/BiasStartupTB__sf.meta" "w")
    fprintf(mtxP "sweep %%L\n" car(errset(sweepNames())))
    close(mtxP)
    errset(mtxDump("/home/mseminario2/vestarv/implementations/asic/castalia/analog/data/raw/BiasStartupTB__sf__idd.csv" abs(i("/V0/PLUS"))))
    errset(mtxDump("/home/mseminario2/vestarv/implementations/asic/castalia/analog/data/raw/BiasStartupTB__sf__vbnc.csv" v("/V_BNC")))
    errset(mtxDump("/home/mseminario2/vestarv/implementations/asic/castalia/analog/data/raw/BiasStartupTB__sf__vbnm.csv" v("/V_BNM")))
    errset(mtxDump("/home/mseminario2/vestarv/implementations/asic/castalia/analog/data/raw/BiasStartupTB__sf__vbpc.csv" v("/V_BPC")))
    errset(mtxDump("/home/mseminario2/vestarv/implementations/asic/castalia/analog/data/raw/BiasStartupTB__sf__vbpm.csv" v("/V_BPM")))
    errset(mtxDump("/home/mseminario2/vestarv/implementations/asic/castalia/analog/data/raw/BiasStartupTB__sf__vdd.csv" v("/vdd!")))
    errset(mtxDump("/home/mseminario2/vestarv/implementations/asic/castalia/analog/data/raw/BiasStartupTB__sf__vsgpc.csv" (v("/vdd!") - v("/V_BPC"))))
    errset(mtxDump("/home/mseminario2/vestarv/implementations/asic/castalia/analog/data/raw/BiasStartupTB__sf__vsgpm.csv" (v("/vdd!") - v("/V_BPM"))))
    errset(mtxDump("/home/mseminario2/vestarv/implementations/asic/castalia/analog/data/raw/BiasStartupTB__sf__vsu.csv" v("/BIASGEN/V_SU")))
  )
)

;; ---- corner 4 (sf) / test DCOpTB
when(isDir("/home/mseminario2/chips/castalia/ic/.simulation/castalia/BiasGenCascWideSwing_tb/maestro/results/maestro/Interactive.32/4/DCOpTB/psf")
  openResults("/home/mseminario2/chips/castalia/ic/.simulation/castalia/BiasGenCascWideSwing_tb/maestro/results/maestro/Interactive.32/4/DCOpTB/psf")
  when(member('dcOp results())
    selectResult('dcOp)
    mtxP = outfile("/home/mseminario2/vestarv/implementations/asic/castalia/analog/data/raw/DCOpTB__sf.meta" "w")
    fprintf(mtxP "sweep %%L\n" car(errset(sweepNames())))
    close(mtxP)
    errset(mtxDump("/home/mseminario2/vestarv/implementations/asic/castalia/analog/data/raw/DCOpTB__sf__idd.csv" abs(i("/POWER/SRC_VDD25/PLUS"))))
    errset(mtxDump("/home/mseminario2/vestarv/implementations/asic/castalia/analog/data/raw/DCOpTB__sf__vbnc.csv" v("/V_BNC")))
    errset(mtxDump("/home/mseminario2/vestarv/implementations/asic/castalia/analog/data/raw/DCOpTB__sf__vbnm.csv" v("/V_BNM")))
    errset(mtxDump("/home/mseminario2/vestarv/implementations/asic/castalia/analog/data/raw/DCOpTB__sf__vbpc.csv" v("/V_BPC")))
    errset(mtxDump("/home/mseminario2/vestarv/implementations/asic/castalia/analog/data/raw/DCOpTB__sf__vbpm.csv" v("/V_BPM")))
    errset(mtxDump("/home/mseminario2/vestarv/implementations/asic/castalia/analog/data/raw/DCOpTB__sf__vsgpc.csv" (v("/vdd!") - v("/V_BPC"))))
    errset(mtxDump("/home/mseminario2/vestarv/implementations/asic/castalia/analog/data/raw/DCOpTB__sf__vsgpm.csv" (v("/vdd!") - v("/V_BPM"))))
  )
)

;; ---- corner 4 (sf) / test bg_adj
when(isDir("/home/mseminario2/chips/castalia/ic/.simulation/castalia/BiasGenCascWideSwing_tb/maestro/results/maestro/Interactive.32/4/bg_adj/psf")
  openResults("/home/mseminario2/chips/castalia/ic/.simulation/castalia/BiasGenCascWideSwing_tb/maestro/results/maestro/Interactive.32/4/bg_adj/psf")
  when(member('dc results())
    selectResult('dc)
    mtxP = outfile("/home/mseminario2/vestarv/implementations/asic/castalia/analog/data/raw/bg_adj__sf.meta" "w")
    fprintf(mtxP "sweep %%L\n" car(errset(sweepNames())))
    close(mtxP)
    errset(mtxDump("/home/mseminario2/vestarv/implementations/asic/castalia/analog/data/raw/bg_adj__sf__idd.csv" abs(i("/POWER/SRC_VDD25/PLUS"))))
    errset(mtxDump("/home/mseminario2/vestarv/implementations/asic/castalia/analog/data/raw/bg_adj__sf__vbnc.csv" v("/V_BNC")))
    errset(mtxDump("/home/mseminario2/vestarv/implementations/asic/castalia/analog/data/raw/bg_adj__sf__vbnm.csv" v("/V_BNM")))
    errset(mtxDump("/home/mseminario2/vestarv/implementations/asic/castalia/analog/data/raw/bg_adj__sf__vbpc.csv" v("/V_BPC")))
    errset(mtxDump("/home/mseminario2/vestarv/implementations/asic/castalia/analog/data/raw/bg_adj__sf__vbpm.csv" v("/V_BPM")))
    errset(mtxDump("/home/mseminario2/vestarv/implementations/asic/castalia/analog/data/raw/bg_adj__sf__vsgpc.csv" (v("/vdd!") - v("/V_BPC"))))
    errset(mtxDump("/home/mseminario2/vestarv/implementations/asic/castalia/analog/data/raw/bg_adj__sf__vsgpm.csv" (v("/vdd!") - v("/V_BPM"))))
  )
)

;; ---- corner 4 (sf) / test bg_temp
when(isDir("/home/mseminario2/chips/castalia/ic/.simulation/castalia/BiasGenCascWideSwing_tb/maestro/results/maestro/Interactive.32/4/bg_temp/psf")
  openResults("/home/mseminario2/chips/castalia/ic/.simulation/castalia/BiasGenCascWideSwing_tb/maestro/results/maestro/Interactive.32/4/bg_temp/psf")
  when(member('dc results())
    selectResult('dc)
    mtxP = outfile("/home/mseminario2/vestarv/implementations/asic/castalia/analog/data/raw/bg_temp__sf.meta" "w")
    fprintf(mtxP "sweep %%L\n" car(errset(sweepNames())))
    close(mtxP)
    errset(mtxDump("/home/mseminario2/vestarv/implementations/asic/castalia/analog/data/raw/bg_temp__sf__idd.csv" abs(i("/POWER/SRC_VDD25/PLUS"))))
    errset(mtxDump("/home/mseminario2/vestarv/implementations/asic/castalia/analog/data/raw/bg_temp__sf__vbnc.csv" v("/V_BNC")))
    errset(mtxDump("/home/mseminario2/vestarv/implementations/asic/castalia/analog/data/raw/bg_temp__sf__vbnm.csv" v("/V_BNM")))
    errset(mtxDump("/home/mseminario2/vestarv/implementations/asic/castalia/analog/data/raw/bg_temp__sf__vbpc.csv" v("/V_BPC")))
    errset(mtxDump("/home/mseminario2/vestarv/implementations/asic/castalia/analog/data/raw/bg_temp__sf__vbpm.csv" v("/V_BPM")))
    errset(mtxDump("/home/mseminario2/vestarv/implementations/asic/castalia/analog/data/raw/bg_temp__sf__vsgpc.csv" (v("/vdd!") - v("/V_BPC"))))
    errset(mtxDump("/home/mseminario2/vestarv/implementations/asic/castalia/analog/data/raw/bg_temp__sf__vsgpm.csv" (v("/vdd!") - v("/V_BPM"))))
  )
)

;; ---- corner 4 (sf) / test bg_vdd
when(isDir("/home/mseminario2/chips/castalia/ic/.simulation/castalia/BiasGenCascWideSwing_tb/maestro/results/maestro/Interactive.32/4/bg_vdd/psf")
  openResults("/home/mseminario2/chips/castalia/ic/.simulation/castalia/BiasGenCascWideSwing_tb/maestro/results/maestro/Interactive.32/4/bg_vdd/psf")
  when(member('dc results())
    selectResult('dc)
    mtxP = outfile("/home/mseminario2/vestarv/implementations/asic/castalia/analog/data/raw/bg_vdd__sf.meta" "w")
    fprintf(mtxP "sweep %%L\n" car(errset(sweepNames())))
    close(mtxP)
    errset(mtxDump("/home/mseminario2/vestarv/implementations/asic/castalia/analog/data/raw/bg_vdd__sf__idd.csv" abs(i("/POWER/SRC_VDD25/PLUS"))))
    errset(mtxDump("/home/mseminario2/vestarv/implementations/asic/castalia/analog/data/raw/bg_vdd__sf__vbnc.csv" v("/V_BNC")))
    errset(mtxDump("/home/mseminario2/vestarv/implementations/asic/castalia/analog/data/raw/bg_vdd__sf__vbnm.csv" v("/V_BNM")))
    errset(mtxDump("/home/mseminario2/vestarv/implementations/asic/castalia/analog/data/raw/bg_vdd__sf__vbpc.csv" v("/V_BPC")))
    errset(mtxDump("/home/mseminario2/vestarv/implementations/asic/castalia/analog/data/raw/bg_vdd__sf__vbpm.csv" v("/V_BPM")))
    errset(mtxDump("/home/mseminario2/vestarv/implementations/asic/castalia/analog/data/raw/bg_vdd__sf__vsgpc.csv" (v("/vdd!") - v("/V_BPC"))))
    errset(mtxDump("/home/mseminario2/vestarv/implementations/asic/castalia/analog/data/raw/bg_vdd__sf__vsgpm.csv" (v("/vdd!") - v("/V_BPM"))))
  )
)

;; ---- corner 5 (ss) / test BiasStartupTB
when(isDir("/home/mseminario2/chips/castalia/ic/.simulation/castalia/BiasGenCascWideSwing_tb/maestro/results/maestro/Interactive.32/5/BiasStartupTB/psf")
  openResults("/home/mseminario2/chips/castalia/ic/.simulation/castalia/BiasGenCascWideSwing_tb/maestro/results/maestro/Interactive.32/5/BiasStartupTB/psf")
  when(member('tran results())
    selectResult('tran)
    mtxP = outfile("/home/mseminario2/vestarv/implementations/asic/castalia/analog/data/raw/BiasStartupTB__ss.meta" "w")
    fprintf(mtxP "sweep %%L\n" car(errset(sweepNames())))
    close(mtxP)
    errset(mtxDump("/home/mseminario2/vestarv/implementations/asic/castalia/analog/data/raw/BiasStartupTB__ss__idd.csv" abs(i("/V0/PLUS"))))
    errset(mtxDump("/home/mseminario2/vestarv/implementations/asic/castalia/analog/data/raw/BiasStartupTB__ss__vbnc.csv" v("/V_BNC")))
    errset(mtxDump("/home/mseminario2/vestarv/implementations/asic/castalia/analog/data/raw/BiasStartupTB__ss__vbnm.csv" v("/V_BNM")))
    errset(mtxDump("/home/mseminario2/vestarv/implementations/asic/castalia/analog/data/raw/BiasStartupTB__ss__vbpc.csv" v("/V_BPC")))
    errset(mtxDump("/home/mseminario2/vestarv/implementations/asic/castalia/analog/data/raw/BiasStartupTB__ss__vbpm.csv" v("/V_BPM")))
    errset(mtxDump("/home/mseminario2/vestarv/implementations/asic/castalia/analog/data/raw/BiasStartupTB__ss__vdd.csv" v("/vdd!")))
    errset(mtxDump("/home/mseminario2/vestarv/implementations/asic/castalia/analog/data/raw/BiasStartupTB__ss__vsgpc.csv" (v("/vdd!") - v("/V_BPC"))))
    errset(mtxDump("/home/mseminario2/vestarv/implementations/asic/castalia/analog/data/raw/BiasStartupTB__ss__vsgpm.csv" (v("/vdd!") - v("/V_BPM"))))
    errset(mtxDump("/home/mseminario2/vestarv/implementations/asic/castalia/analog/data/raw/BiasStartupTB__ss__vsu.csv" v("/BIASGEN/V_SU")))
  )
)

;; ---- corner 5 (ss) / test DCOpTB
when(isDir("/home/mseminario2/chips/castalia/ic/.simulation/castalia/BiasGenCascWideSwing_tb/maestro/results/maestro/Interactive.32/5/DCOpTB/psf")
  openResults("/home/mseminario2/chips/castalia/ic/.simulation/castalia/BiasGenCascWideSwing_tb/maestro/results/maestro/Interactive.32/5/DCOpTB/psf")
  when(member('dcOp results())
    selectResult('dcOp)
    mtxP = outfile("/home/mseminario2/vestarv/implementations/asic/castalia/analog/data/raw/DCOpTB__ss.meta" "w")
    fprintf(mtxP "sweep %%L\n" car(errset(sweepNames())))
    close(mtxP)
    errset(mtxDump("/home/mseminario2/vestarv/implementations/asic/castalia/analog/data/raw/DCOpTB__ss__idd.csv" abs(i("/POWER/SRC_VDD25/PLUS"))))
    errset(mtxDump("/home/mseminario2/vestarv/implementations/asic/castalia/analog/data/raw/DCOpTB__ss__vbnc.csv" v("/V_BNC")))
    errset(mtxDump("/home/mseminario2/vestarv/implementations/asic/castalia/analog/data/raw/DCOpTB__ss__vbnm.csv" v("/V_BNM")))
    errset(mtxDump("/home/mseminario2/vestarv/implementations/asic/castalia/analog/data/raw/DCOpTB__ss__vbpc.csv" v("/V_BPC")))
    errset(mtxDump("/home/mseminario2/vestarv/implementations/asic/castalia/analog/data/raw/DCOpTB__ss__vbpm.csv" v("/V_BPM")))
    errset(mtxDump("/home/mseminario2/vestarv/implementations/asic/castalia/analog/data/raw/DCOpTB__ss__vsgpc.csv" (v("/vdd!") - v("/V_BPC"))))
    errset(mtxDump("/home/mseminario2/vestarv/implementations/asic/castalia/analog/data/raw/DCOpTB__ss__vsgpm.csv" (v("/vdd!") - v("/V_BPM"))))
  )
)

;; ---- corner 5 (ss) / test bg_adj
when(isDir("/home/mseminario2/chips/castalia/ic/.simulation/castalia/BiasGenCascWideSwing_tb/maestro/results/maestro/Interactive.32/5/bg_adj/psf")
  openResults("/home/mseminario2/chips/castalia/ic/.simulation/castalia/BiasGenCascWideSwing_tb/maestro/results/maestro/Interactive.32/5/bg_adj/psf")
  when(member('dc results())
    selectResult('dc)
    mtxP = outfile("/home/mseminario2/vestarv/implementations/asic/castalia/analog/data/raw/bg_adj__ss.meta" "w")
    fprintf(mtxP "sweep %%L\n" car(errset(sweepNames())))
    close(mtxP)
    errset(mtxDump("/home/mseminario2/vestarv/implementations/asic/castalia/analog/data/raw/bg_adj__ss__idd.csv" abs(i("/POWER/SRC_VDD25/PLUS"))))
    errset(mtxDump("/home/mseminario2/vestarv/implementations/asic/castalia/analog/data/raw/bg_adj__ss__vbnc.csv" v("/V_BNC")))
    errset(mtxDump("/home/mseminario2/vestarv/implementations/asic/castalia/analog/data/raw/bg_adj__ss__vbnm.csv" v("/V_BNM")))
    errset(mtxDump("/home/mseminario2/vestarv/implementations/asic/castalia/analog/data/raw/bg_adj__ss__vbpc.csv" v("/V_BPC")))
    errset(mtxDump("/home/mseminario2/vestarv/implementations/asic/castalia/analog/data/raw/bg_adj__ss__vbpm.csv" v("/V_BPM")))
    errset(mtxDump("/home/mseminario2/vestarv/implementations/asic/castalia/analog/data/raw/bg_adj__ss__vsgpc.csv" (v("/vdd!") - v("/V_BPC"))))
    errset(mtxDump("/home/mseminario2/vestarv/implementations/asic/castalia/analog/data/raw/bg_adj__ss__vsgpm.csv" (v("/vdd!") - v("/V_BPM"))))
  )
)

;; ---- corner 5 (ss) / test bg_temp
when(isDir("/home/mseminario2/chips/castalia/ic/.simulation/castalia/BiasGenCascWideSwing_tb/maestro/results/maestro/Interactive.32/5/bg_temp/psf")
  openResults("/home/mseminario2/chips/castalia/ic/.simulation/castalia/BiasGenCascWideSwing_tb/maestro/results/maestro/Interactive.32/5/bg_temp/psf")
  when(member('dc results())
    selectResult('dc)
    mtxP = outfile("/home/mseminario2/vestarv/implementations/asic/castalia/analog/data/raw/bg_temp__ss.meta" "w")
    fprintf(mtxP "sweep %%L\n" car(errset(sweepNames())))
    close(mtxP)
    errset(mtxDump("/home/mseminario2/vestarv/implementations/asic/castalia/analog/data/raw/bg_temp__ss__idd.csv" abs(i("/POWER/SRC_VDD25/PLUS"))))
    errset(mtxDump("/home/mseminario2/vestarv/implementations/asic/castalia/analog/data/raw/bg_temp__ss__vbnc.csv" v("/V_BNC")))
    errset(mtxDump("/home/mseminario2/vestarv/implementations/asic/castalia/analog/data/raw/bg_temp__ss__vbnm.csv" v("/V_BNM")))
    errset(mtxDump("/home/mseminario2/vestarv/implementations/asic/castalia/analog/data/raw/bg_temp__ss__vbpc.csv" v("/V_BPC")))
    errset(mtxDump("/home/mseminario2/vestarv/implementations/asic/castalia/analog/data/raw/bg_temp__ss__vbpm.csv" v("/V_BPM")))
    errset(mtxDump("/home/mseminario2/vestarv/implementations/asic/castalia/analog/data/raw/bg_temp__ss__vsgpc.csv" (v("/vdd!") - v("/V_BPC"))))
    errset(mtxDump("/home/mseminario2/vestarv/implementations/asic/castalia/analog/data/raw/bg_temp__ss__vsgpm.csv" (v("/vdd!") - v("/V_BPM"))))
  )
)

;; ---- corner 5 (ss) / test bg_vdd
when(isDir("/home/mseminario2/chips/castalia/ic/.simulation/castalia/BiasGenCascWideSwing_tb/maestro/results/maestro/Interactive.32/5/bg_vdd/psf")
  openResults("/home/mseminario2/chips/castalia/ic/.simulation/castalia/BiasGenCascWideSwing_tb/maestro/results/maestro/Interactive.32/5/bg_vdd/psf")
  when(member('dc results())
    selectResult('dc)
    mtxP = outfile("/home/mseminario2/vestarv/implementations/asic/castalia/analog/data/raw/bg_vdd__ss.meta" "w")
    fprintf(mtxP "sweep %%L\n" car(errset(sweepNames())))
    close(mtxP)
    errset(mtxDump("/home/mseminario2/vestarv/implementations/asic/castalia/analog/data/raw/bg_vdd__ss__idd.csv" abs(i("/POWER/SRC_VDD25/PLUS"))))
    errset(mtxDump("/home/mseminario2/vestarv/implementations/asic/castalia/analog/data/raw/bg_vdd__ss__vbnc.csv" v("/V_BNC")))
    errset(mtxDump("/home/mseminario2/vestarv/implementations/asic/castalia/analog/data/raw/bg_vdd__ss__vbnm.csv" v("/V_BNM")))
    errset(mtxDump("/home/mseminario2/vestarv/implementations/asic/castalia/analog/data/raw/bg_vdd__ss__vbpc.csv" v("/V_BPC")))
    errset(mtxDump("/home/mseminario2/vestarv/implementations/asic/castalia/analog/data/raw/bg_vdd__ss__vbpm.csv" v("/V_BPM")))
    errset(mtxDump("/home/mseminario2/vestarv/implementations/asic/castalia/analog/data/raw/bg_vdd__ss__vsgpc.csv" (v("/vdd!") - v("/V_BPC"))))
    errset(mtxDump("/home/mseminario2/vestarv/implementations/asic/castalia/analog/data/raw/bg_vdd__ss__vsgpm.csv" (v("/vdd!") - v("/V_BPM"))))
  )
)

printf("MTX_EXTRACT_DONE\n")
exit(0)
