;; generated by maestro2tex -- do not edit
procedure(mtxDump(fname wv)
  let((xs ys n p)
    p = outfile(fname "w")
    cond(
      (null(wv) fprintf(p "#nil\n"))
      (drIsWaveform(wv)
        xs = drGetWaveformXVec(wv)
        ys = drGetWaveformYVec(wv)
        n = drVectorLength(xs)
        for(i 0 n-1
          fprintf(p "%.10g %.10g\n" drGetElem(xs i) drGetElem(ys i)))
      )
      (t fprintf(p "#scalar %.10g\n" float(wv)))
    )
    close(p)
    t))

;; ---- corner 61 (pt61) / test px_hg_dc
when(isDir("/home/mseminario2/chips/castalia/ic/.simulation/castalia/tb_anatop_pixel/maestro/results/maestro/Interactive.20/61/ps_iacc_hg/psf")
  openResults("/home/mseminario2/chips/castalia/ic/.simulation/castalia/tb_anatop_pixel/maestro/results/maestro/Interactive.20/61/ps_iacc_hg/psf")
  when(member('dc results())
    selectResult('dc)
    mtxP = outfile("/home/mseminario2/vestarv/implementations/asic/castalia/analog/data/raw/px_hg_dc__pt61.meta" "w")
    fprintf(mtxP "sweep %%L\n" car(errset(sweepNames())))
    close(mtxP)
    errset(mtxDump("/home/mseminario2/vestarv/implementations/asic/castalia/analog/data/raw/px_hg_dc__pt61__grid_rf.csv" VAR("rf")))
    errset(mtxDump("/home/mseminario2/vestarv/implementations/asic/castalia/analog/data/raw/px_hg_dc__pt61__ierr_0.csv" value((((VS("/V_OUT") - VAR("V_CM")) / VAR("rf")) - xval(((VS("/V_OUT") - VAR("V_CM")) / VAR("rf")))) 0)))
    errset(mtxDump("/home/mseminario2/vestarv/implementations/asic/castalia/analog/data/raw/px_hg_dc__pt61__ierr_lsb_max.csv" ymax(abs(clip((((((VS("/V_OUT") - VAR("V_CM")) / VAR("rf")) - xval(((VS("/V_OUT") - VAR("V_CM")) / VAR("rf")))) * VAR("rf")) / 0.002441) (0 - (1.155 / VAR("rf"))) (1.155 / VAR("rf")))))))
    errset(mtxDump("/home/mseminario2/vestarv/implementations/asic/castalia/analog/data/raw/px_hg_dc__pt61__slope_err_0.csv" (value(deriv(((VS("/V_OUT") - VAR("V_CM")) / VAR("rf"))) 0) - 1)))
  )
)

;; ---- corner 62 (ff62) / test px_hg_dc
when(isDir("/home/mseminario2/chips/castalia/ic/.simulation/castalia/tb_anatop_pixel/maestro/results/maestro/Interactive.20/62/ps_iacc_hg/psf")
  openResults("/home/mseminario2/chips/castalia/ic/.simulation/castalia/tb_anatop_pixel/maestro/results/maestro/Interactive.20/62/ps_iacc_hg/psf")
  when(member('dc results())
    selectResult('dc)
    mtxP = outfile("/home/mseminario2/vestarv/implementations/asic/castalia/analog/data/raw/px_hg_dc__ff62.meta" "w")
    fprintf(mtxP "sweep %%L\n" car(errset(sweepNames())))
    close(mtxP)
    errset(mtxDump("/home/mseminario2/vestarv/implementations/asic/castalia/analog/data/raw/px_hg_dc__ff62__grid_rf.csv" VAR("rf")))
    errset(mtxDump("/home/mseminario2/vestarv/implementations/asic/castalia/analog/data/raw/px_hg_dc__ff62__ierr_0.csv" value((((VS("/V_OUT") - VAR("V_CM")) / VAR("rf")) - xval(((VS("/V_OUT") - VAR("V_CM")) / VAR("rf")))) 0)))
    errset(mtxDump("/home/mseminario2/vestarv/implementations/asic/castalia/analog/data/raw/px_hg_dc__ff62__ierr_lsb_max.csv" ymax(abs(clip((((((VS("/V_OUT") - VAR("V_CM")) / VAR("rf")) - xval(((VS("/V_OUT") - VAR("V_CM")) / VAR("rf")))) * VAR("rf")) / 0.002441) (0 - (1.155 / VAR("rf"))) (1.155 / VAR("rf")))))))
    errset(mtxDump("/home/mseminario2/vestarv/implementations/asic/castalia/analog/data/raw/px_hg_dc__ff62__slope_err_0.csv" (value(deriv(((VS("/V_OUT") - VAR("V_CM")) / VAR("rf"))) 0) - 1)))
  )
)

;; ---- corner 63 (fs63) / test px_hg_dc
when(isDir("/home/mseminario2/chips/castalia/ic/.simulation/castalia/tb_anatop_pixel/maestro/results/maestro/Interactive.20/63/ps_iacc_hg/psf")
  openResults("/home/mseminario2/chips/castalia/ic/.simulation/castalia/tb_anatop_pixel/maestro/results/maestro/Interactive.20/63/ps_iacc_hg/psf")
  when(member('dc results())
    selectResult('dc)
    mtxP = outfile("/home/mseminario2/vestarv/implementations/asic/castalia/analog/data/raw/px_hg_dc__fs63.meta" "w")
    fprintf(mtxP "sweep %%L\n" car(errset(sweepNames())))
    close(mtxP)
    errset(mtxDump("/home/mseminario2/vestarv/implementations/asic/castalia/analog/data/raw/px_hg_dc__fs63__grid_rf.csv" VAR("rf")))
    errset(mtxDump("/home/mseminario2/vestarv/implementations/asic/castalia/analog/data/raw/px_hg_dc__fs63__ierr_0.csv" value((((VS("/V_OUT") - VAR("V_CM")) / VAR("rf")) - xval(((VS("/V_OUT") - VAR("V_CM")) / VAR("rf")))) 0)))
    errset(mtxDump("/home/mseminario2/vestarv/implementations/asic/castalia/analog/data/raw/px_hg_dc__fs63__ierr_lsb_max.csv" ymax(abs(clip((((((VS("/V_OUT") - VAR("V_CM")) / VAR("rf")) - xval(((VS("/V_OUT") - VAR("V_CM")) / VAR("rf")))) * VAR("rf")) / 0.002441) (0 - (1.155 / VAR("rf"))) (1.155 / VAR("rf")))))))
    errset(mtxDump("/home/mseminario2/vestarv/implementations/asic/castalia/analog/data/raw/px_hg_dc__fs63__slope_err_0.csv" (value(deriv(((VS("/V_OUT") - VAR("V_CM")) / VAR("rf"))) 0) - 1)))
  )
)

;; ---- corner 64 (sf64) / test px_hg_dc
when(isDir("/home/mseminario2/chips/castalia/ic/.simulation/castalia/tb_anatop_pixel/maestro/results/maestro/Interactive.20/64/ps_iacc_hg/psf")
  openResults("/home/mseminario2/chips/castalia/ic/.simulation/castalia/tb_anatop_pixel/maestro/results/maestro/Interactive.20/64/ps_iacc_hg/psf")
  when(member('dc results())
    selectResult('dc)
    mtxP = outfile("/home/mseminario2/vestarv/implementations/asic/castalia/analog/data/raw/px_hg_dc__sf64.meta" "w")
    fprintf(mtxP "sweep %%L\n" car(errset(sweepNames())))
    close(mtxP)
    errset(mtxDump("/home/mseminario2/vestarv/implementations/asic/castalia/analog/data/raw/px_hg_dc__sf64__grid_rf.csv" VAR("rf")))
    errset(mtxDump("/home/mseminario2/vestarv/implementations/asic/castalia/analog/data/raw/px_hg_dc__sf64__ierr_0.csv" value((((VS("/V_OUT") - VAR("V_CM")) / VAR("rf")) - xval(((VS("/V_OUT") - VAR("V_CM")) / VAR("rf")))) 0)))
    errset(mtxDump("/home/mseminario2/vestarv/implementations/asic/castalia/analog/data/raw/px_hg_dc__sf64__ierr_lsb_max.csv" ymax(abs(clip((((((VS("/V_OUT") - VAR("V_CM")) / VAR("rf")) - xval(((VS("/V_OUT") - VAR("V_CM")) / VAR("rf")))) * VAR("rf")) / 0.002441) (0 - (1.155 / VAR("rf"))) (1.155 / VAR("rf")))))))
    errset(mtxDump("/home/mseminario2/vestarv/implementations/asic/castalia/analog/data/raw/px_hg_dc__sf64__slope_err_0.csv" (value(deriv(((VS("/V_OUT") - VAR("V_CM")) / VAR("rf"))) 0) - 1)))
  )
)

;; ---- corner 65 (ss65) / test px_hg_dc
when(isDir("/home/mseminario2/chips/castalia/ic/.simulation/castalia/tb_anatop_pixel/maestro/results/maestro/Interactive.20/65/ps_iacc_hg/psf")
  openResults("/home/mseminario2/chips/castalia/ic/.simulation/castalia/tb_anatop_pixel/maestro/results/maestro/Interactive.20/65/ps_iacc_hg/psf")
  when(member('dc results())
    selectResult('dc)
    mtxP = outfile("/home/mseminario2/vestarv/implementations/asic/castalia/analog/data/raw/px_hg_dc__ss65.meta" "w")
    fprintf(mtxP "sweep %%L\n" car(errset(sweepNames())))
    close(mtxP)
    errset(mtxDump("/home/mseminario2/vestarv/implementations/asic/castalia/analog/data/raw/px_hg_dc__ss65__grid_rf.csv" VAR("rf")))
    errset(mtxDump("/home/mseminario2/vestarv/implementations/asic/castalia/analog/data/raw/px_hg_dc__ss65__ierr_0.csv" value((((VS("/V_OUT") - VAR("V_CM")) / VAR("rf")) - xval(((VS("/V_OUT") - VAR("V_CM")) / VAR("rf")))) 0)))
    errset(mtxDump("/home/mseminario2/vestarv/implementations/asic/castalia/analog/data/raw/px_hg_dc__ss65__ierr_lsb_max.csv" ymax(abs(clip((((((VS("/V_OUT") - VAR("V_CM")) / VAR("rf")) - xval(((VS("/V_OUT") - VAR("V_CM")) / VAR("rf")))) * VAR("rf")) / 0.002441) (0 - (1.155 / VAR("rf"))) (1.155 / VAR("rf")))))))
    errset(mtxDump("/home/mseminario2/vestarv/implementations/asic/castalia/analog/data/raw/px_hg_dc__ss65__slope_err_0.csv" (value(deriv(((VS("/V_OUT") - VAR("V_CM")) / VAR("rf"))) 0) - 1)))
  )
)

;; ---- corner 66 (pt66) / test px_hg_dc
when(isDir("/home/mseminario2/chips/castalia/ic/.simulation/castalia/tb_anatop_pixel/maestro/results/maestro/Interactive.20/66/ps_iacc_hg/psf")
  openResults("/home/mseminario2/chips/castalia/ic/.simulation/castalia/tb_anatop_pixel/maestro/results/maestro/Interactive.20/66/ps_iacc_hg/psf")
  when(member('dc results())
    selectResult('dc)
    mtxP = outfile("/home/mseminario2/vestarv/implementations/asic/castalia/analog/data/raw/px_hg_dc__pt66.meta" "w")
    fprintf(mtxP "sweep %%L\n" car(errset(sweepNames())))
    close(mtxP)
    errset(mtxDump("/home/mseminario2/vestarv/implementations/asic/castalia/analog/data/raw/px_hg_dc__pt66__grid_rf.csv" VAR("rf")))
    errset(mtxDump("/home/mseminario2/vestarv/implementations/asic/castalia/analog/data/raw/px_hg_dc__pt66__ierr_0.csv" value((((VS("/V_OUT") - VAR("V_CM")) / VAR("rf")) - xval(((VS("/V_OUT") - VAR("V_CM")) / VAR("rf")))) 0)))
    errset(mtxDump("/home/mseminario2/vestarv/implementations/asic/castalia/analog/data/raw/px_hg_dc__pt66__ierr_lsb_max.csv" ymax(abs(clip((((((VS("/V_OUT") - VAR("V_CM")) / VAR("rf")) - xval(((VS("/V_OUT") - VAR("V_CM")) / VAR("rf")))) * VAR("rf")) / 0.002441) (0 - (1.155 / VAR("rf"))) (1.155 / VAR("rf")))))))
    errset(mtxDump("/home/mseminario2/vestarv/implementations/asic/castalia/analog/data/raw/px_hg_dc__pt66__slope_err_0.csv" (value(deriv(((VS("/V_OUT") - VAR("V_CM")) / VAR("rf"))) 0) - 1)))
  )
)

;; ---- corner 67 (ff67) / test px_hg_dc
when(isDir("/home/mseminario2/chips/castalia/ic/.simulation/castalia/tb_anatop_pixel/maestro/results/maestro/Interactive.20/67/ps_iacc_hg/psf")
  openResults("/home/mseminario2/chips/castalia/ic/.simulation/castalia/tb_anatop_pixel/maestro/results/maestro/Interactive.20/67/ps_iacc_hg/psf")
  when(member('dc results())
    selectResult('dc)
    mtxP = outfile("/home/mseminario2/vestarv/implementations/asic/castalia/analog/data/raw/px_hg_dc__ff67.meta" "w")
    fprintf(mtxP "sweep %%L\n" car(errset(sweepNames())))
    close(mtxP)
    errset(mtxDump("/home/mseminario2/vestarv/implementations/asic/castalia/analog/data/raw/px_hg_dc__ff67__grid_rf.csv" VAR("rf")))
    errset(mtxDump("/home/mseminario2/vestarv/implementations/asic/castalia/analog/data/raw/px_hg_dc__ff67__ierr_0.csv" value((((VS("/V_OUT") - VAR("V_CM")) / VAR("rf")) - xval(((VS("/V_OUT") - VAR("V_CM")) / VAR("rf")))) 0)))
    errset(mtxDump("/home/mseminario2/vestarv/implementations/asic/castalia/analog/data/raw/px_hg_dc__ff67__ierr_lsb_max.csv" ymax(abs(clip((((((VS("/V_OUT") - VAR("V_CM")) / VAR("rf")) - xval(((VS("/V_OUT") - VAR("V_CM")) / VAR("rf")))) * VAR("rf")) / 0.002441) (0 - (1.155 / VAR("rf"))) (1.155 / VAR("rf")))))))
    errset(mtxDump("/home/mseminario2/vestarv/implementations/asic/castalia/analog/data/raw/px_hg_dc__ff67__slope_err_0.csv" (value(deriv(((VS("/V_OUT") - VAR("V_CM")) / VAR("rf"))) 0) - 1)))
  )
)

;; ---- corner 68 (fs68) / test px_hg_dc
when(isDir("/home/mseminario2/chips/castalia/ic/.simulation/castalia/tb_anatop_pixel/maestro/results/maestro/Interactive.20/68/ps_iacc_hg/psf")
  openResults("/home/mseminario2/chips/castalia/ic/.simulation/castalia/tb_anatop_pixel/maestro/results/maestro/Interactive.20/68/ps_iacc_hg/psf")
  when(member('dc results())
    selectResult('dc)
    mtxP = outfile("/home/mseminario2/vestarv/implementations/asic/castalia/analog/data/raw/px_hg_dc__fs68.meta" "w")
    fprintf(mtxP "sweep %%L\n" car(errset(sweepNames())))
    close(mtxP)
    errset(mtxDump("/home/mseminario2/vestarv/implementations/asic/castalia/analog/data/raw/px_hg_dc__fs68__grid_rf.csv" VAR("rf")))
    errset(mtxDump("/home/mseminario2/vestarv/implementations/asic/castalia/analog/data/raw/px_hg_dc__fs68__ierr_0.csv" value((((VS("/V_OUT") - VAR("V_CM")) / VAR("rf")) - xval(((VS("/V_OUT") - VAR("V_CM")) / VAR("rf")))) 0)))
    errset(mtxDump("/home/mseminario2/vestarv/implementations/asic/castalia/analog/data/raw/px_hg_dc__fs68__ierr_lsb_max.csv" ymax(abs(clip((((((VS("/V_OUT") - VAR("V_CM")) / VAR("rf")) - xval(((VS("/V_OUT") - VAR("V_CM")) / VAR("rf")))) * VAR("rf")) / 0.002441) (0 - (1.155 / VAR("rf"))) (1.155 / VAR("rf")))))))
    errset(mtxDump("/home/mseminario2/vestarv/implementations/asic/castalia/analog/data/raw/px_hg_dc__fs68__slope_err_0.csv" (value(deriv(((VS("/V_OUT") - VAR("V_CM")) / VAR("rf"))) 0) - 1)))
  )
)

;; ---- corner 69 (sf69) / test px_hg_dc
when(isDir("/home/mseminario2/chips/castalia/ic/.simulation/castalia/tb_anatop_pixel/maestro/results/maestro/Interactive.20/69/ps_iacc_hg/psf")
  openResults("/home/mseminario2/chips/castalia/ic/.simulation/castalia/tb_anatop_pixel/maestro/results/maestro/Interactive.20/69/ps_iacc_hg/psf")
  when(member('dc results())
    selectResult('dc)
    mtxP = outfile("/home/mseminario2/vestarv/implementations/asic/castalia/analog/data/raw/px_hg_dc__sf69.meta" "w")
    fprintf(mtxP "sweep %%L\n" car(errset(sweepNames())))
    close(mtxP)
    errset(mtxDump("/home/mseminario2/vestarv/implementations/asic/castalia/analog/data/raw/px_hg_dc__sf69__grid_rf.csv" VAR("rf")))
    errset(mtxDump("/home/mseminario2/vestarv/implementations/asic/castalia/analog/data/raw/px_hg_dc__sf69__ierr_0.csv" value((((VS("/V_OUT") - VAR("V_CM")) / VAR("rf")) - xval(((VS("/V_OUT") - VAR("V_CM")) / VAR("rf")))) 0)))
    errset(mtxDump("/home/mseminario2/vestarv/implementations/asic/castalia/analog/data/raw/px_hg_dc__sf69__ierr_lsb_max.csv" ymax(abs(clip((((((VS("/V_OUT") - VAR("V_CM")) / VAR("rf")) - xval(((VS("/V_OUT") - VAR("V_CM")) / VAR("rf")))) * VAR("rf")) / 0.002441) (0 - (1.155 / VAR("rf"))) (1.155 / VAR("rf")))))))
    errset(mtxDump("/home/mseminario2/vestarv/implementations/asic/castalia/analog/data/raw/px_hg_dc__sf69__slope_err_0.csv" (value(deriv(((VS("/V_OUT") - VAR("V_CM")) / VAR("rf"))) 0) - 1)))
  )
)

;; ---- corner 70 (ss70) / test px_hg_dc
when(isDir("/home/mseminario2/chips/castalia/ic/.simulation/castalia/tb_anatop_pixel/maestro/results/maestro/Interactive.20/70/ps_iacc_hg/psf")
  openResults("/home/mseminario2/chips/castalia/ic/.simulation/castalia/tb_anatop_pixel/maestro/results/maestro/Interactive.20/70/ps_iacc_hg/psf")
  when(member('dc results())
    selectResult('dc)
    mtxP = outfile("/home/mseminario2/vestarv/implementations/asic/castalia/analog/data/raw/px_hg_dc__ss70.meta" "w")
    fprintf(mtxP "sweep %%L\n" car(errset(sweepNames())))
    close(mtxP)
    errset(mtxDump("/home/mseminario2/vestarv/implementations/asic/castalia/analog/data/raw/px_hg_dc__ss70__grid_rf.csv" VAR("rf")))
    errset(mtxDump("/home/mseminario2/vestarv/implementations/asic/castalia/analog/data/raw/px_hg_dc__ss70__ierr_0.csv" value((((VS("/V_OUT") - VAR("V_CM")) / VAR("rf")) - xval(((VS("/V_OUT") - VAR("V_CM")) / VAR("rf")))) 0)))
    errset(mtxDump("/home/mseminario2/vestarv/implementations/asic/castalia/analog/data/raw/px_hg_dc__ss70__ierr_lsb_max.csv" ymax(abs(clip((((((VS("/V_OUT") - VAR("V_CM")) / VAR("rf")) - xval(((VS("/V_OUT") - VAR("V_CM")) / VAR("rf")))) * VAR("rf")) / 0.002441) (0 - (1.155 / VAR("rf"))) (1.155 / VAR("rf")))))))
    errset(mtxDump("/home/mseminario2/vestarv/implementations/asic/castalia/analog/data/raw/px_hg_dc__ss70__slope_err_0.csv" (value(deriv(((VS("/V_OUT") - VAR("V_CM")) / VAR("rf"))) 0) - 1)))
  )
)

;; ---- corner 71 (pt71) / test px_hg_dc
when(isDir("/home/mseminario2/chips/castalia/ic/.simulation/castalia/tb_anatop_pixel/maestro/results/maestro/Interactive.20/71/ps_iacc_hg/psf")
  openResults("/home/mseminario2/chips/castalia/ic/.simulation/castalia/tb_anatop_pixel/maestro/results/maestro/Interactive.20/71/ps_iacc_hg/psf")
  when(member('dc results())
    selectResult('dc)
    mtxP = outfile("/home/mseminario2/vestarv/implementations/asic/castalia/analog/data/raw/px_hg_dc__pt71.meta" "w")
    fprintf(mtxP "sweep %%L\n" car(errset(sweepNames())))
    close(mtxP)
    errset(mtxDump("/home/mseminario2/vestarv/implementations/asic/castalia/analog/data/raw/px_hg_dc__pt71__grid_rf.csv" VAR("rf")))
    errset(mtxDump("/home/mseminario2/vestarv/implementations/asic/castalia/analog/data/raw/px_hg_dc__pt71__ierr_0.csv" value((((VS("/V_OUT") - VAR("V_CM")) / VAR("rf")) - xval(((VS("/V_OUT") - VAR("V_CM")) / VAR("rf")))) 0)))
    errset(mtxDump("/home/mseminario2/vestarv/implementations/asic/castalia/analog/data/raw/px_hg_dc__pt71__ierr_lsb_max.csv" ymax(abs(clip((((((VS("/V_OUT") - VAR("V_CM")) / VAR("rf")) - xval(((VS("/V_OUT") - VAR("V_CM")) / VAR("rf")))) * VAR("rf")) / 0.002441) (0 - (1.155 / VAR("rf"))) (1.155 / VAR("rf")))))))
    errset(mtxDump("/home/mseminario2/vestarv/implementations/asic/castalia/analog/data/raw/px_hg_dc__pt71__slope_err_0.csv" (value(deriv(((VS("/V_OUT") - VAR("V_CM")) / VAR("rf"))) 0) - 1)))
  )
)

;; ---- corner 72 (ff72) / test px_hg_dc
when(isDir("/home/mseminario2/chips/castalia/ic/.simulation/castalia/tb_anatop_pixel/maestro/results/maestro/Interactive.20/72/ps_iacc_hg/psf")
  openResults("/home/mseminario2/chips/castalia/ic/.simulation/castalia/tb_anatop_pixel/maestro/results/maestro/Interactive.20/72/ps_iacc_hg/psf")
  when(member('dc results())
    selectResult('dc)
    mtxP = outfile("/home/mseminario2/vestarv/implementations/asic/castalia/analog/data/raw/px_hg_dc__ff72.meta" "w")
    fprintf(mtxP "sweep %%L\n" car(errset(sweepNames())))
    close(mtxP)
    errset(mtxDump("/home/mseminario2/vestarv/implementations/asic/castalia/analog/data/raw/px_hg_dc__ff72__grid_rf.csv" VAR("rf")))
    errset(mtxDump("/home/mseminario2/vestarv/implementations/asic/castalia/analog/data/raw/px_hg_dc__ff72__ierr_0.csv" value((((VS("/V_OUT") - VAR("V_CM")) / VAR("rf")) - xval(((VS("/V_OUT") - VAR("V_CM")) / VAR("rf")))) 0)))
    errset(mtxDump("/home/mseminario2/vestarv/implementations/asic/castalia/analog/data/raw/px_hg_dc__ff72__ierr_lsb_max.csv" ymax(abs(clip((((((VS("/V_OUT") - VAR("V_CM")) / VAR("rf")) - xval(((VS("/V_OUT") - VAR("V_CM")) / VAR("rf")))) * VAR("rf")) / 0.002441) (0 - (1.155 / VAR("rf"))) (1.155 / VAR("rf")))))))
    errset(mtxDump("/home/mseminario2/vestarv/implementations/asic/castalia/analog/data/raw/px_hg_dc__ff72__slope_err_0.csv" (value(deriv(((VS("/V_OUT") - VAR("V_CM")) / VAR("rf"))) 0) - 1)))
  )
)

;; ---- corner 73 (fs73) / test px_hg_dc
when(isDir("/home/mseminario2/chips/castalia/ic/.simulation/castalia/tb_anatop_pixel/maestro/results/maestro/Interactive.20/73/ps_iacc_hg/psf")
  openResults("/home/mseminario2/chips/castalia/ic/.simulation/castalia/tb_anatop_pixel/maestro/results/maestro/Interactive.20/73/ps_iacc_hg/psf")
  when(member('dc results())
    selectResult('dc)
    mtxP = outfile("/home/mseminario2/vestarv/implementations/asic/castalia/analog/data/raw/px_hg_dc__fs73.meta" "w")
    fprintf(mtxP "sweep %%L\n" car(errset(sweepNames())))
    close(mtxP)
    errset(mtxDump("/home/mseminario2/vestarv/implementations/asic/castalia/analog/data/raw/px_hg_dc__fs73__grid_rf.csv" VAR("rf")))
    errset(mtxDump("/home/mseminario2/vestarv/implementations/asic/castalia/analog/data/raw/px_hg_dc__fs73__ierr_0.csv" value((((VS("/V_OUT") - VAR("V_CM")) / VAR("rf")) - xval(((VS("/V_OUT") - VAR("V_CM")) / VAR("rf")))) 0)))
    errset(mtxDump("/home/mseminario2/vestarv/implementations/asic/castalia/analog/data/raw/px_hg_dc__fs73__ierr_lsb_max.csv" ymax(abs(clip((((((VS("/V_OUT") - VAR("V_CM")) / VAR("rf")) - xval(((VS("/V_OUT") - VAR("V_CM")) / VAR("rf")))) * VAR("rf")) / 0.002441) (0 - (1.155 / VAR("rf"))) (1.155 / VAR("rf")))))))
    errset(mtxDump("/home/mseminario2/vestarv/implementations/asic/castalia/analog/data/raw/px_hg_dc__fs73__slope_err_0.csv" (value(deriv(((VS("/V_OUT") - VAR("V_CM")) / VAR("rf"))) 0) - 1)))
  )
)

;; ---- corner 74 (sf74) / test px_hg_dc
when(isDir("/home/mseminario2/chips/castalia/ic/.simulation/castalia/tb_anatop_pixel/maestro/results/maestro/Interactive.20/74/ps_iacc_hg/psf")
  openResults("/home/mseminario2/chips/castalia/ic/.simulation/castalia/tb_anatop_pixel/maestro/results/maestro/Interactive.20/74/ps_iacc_hg/psf")
  when(member('dc results())
    selectResult('dc)
    mtxP = outfile("/home/mseminario2/vestarv/implementations/asic/castalia/analog/data/raw/px_hg_dc__sf74.meta" "w")
    fprintf(mtxP "sweep %%L\n" car(errset(sweepNames())))
    close(mtxP)
    errset(mtxDump("/home/mseminario2/vestarv/implementations/asic/castalia/analog/data/raw/px_hg_dc__sf74__grid_rf.csv" VAR("rf")))
    errset(mtxDump("/home/mseminario2/vestarv/implementations/asic/castalia/analog/data/raw/px_hg_dc__sf74__ierr_0.csv" value((((VS("/V_OUT") - VAR("V_CM")) / VAR("rf")) - xval(((VS("/V_OUT") - VAR("V_CM")) / VAR("rf")))) 0)))
    errset(mtxDump("/home/mseminario2/vestarv/implementations/asic/castalia/analog/data/raw/px_hg_dc__sf74__ierr_lsb_max.csv" ymax(abs(clip((((((VS("/V_OUT") - VAR("V_CM")) / VAR("rf")) - xval(((VS("/V_OUT") - VAR("V_CM")) / VAR("rf")))) * VAR("rf")) / 0.002441) (0 - (1.155 / VAR("rf"))) (1.155 / VAR("rf")))))))
    errset(mtxDump("/home/mseminario2/vestarv/implementations/asic/castalia/analog/data/raw/px_hg_dc__sf74__slope_err_0.csv" (value(deriv(((VS("/V_OUT") - VAR("V_CM")) / VAR("rf"))) 0) - 1)))
  )
)

;; ---- corner 75 (ss75) / test px_hg_dc
when(isDir("/home/mseminario2/chips/castalia/ic/.simulation/castalia/tb_anatop_pixel/maestro/results/maestro/Interactive.20/75/ps_iacc_hg/psf")
  openResults("/home/mseminario2/chips/castalia/ic/.simulation/castalia/tb_anatop_pixel/maestro/results/maestro/Interactive.20/75/ps_iacc_hg/psf")
  when(member('dc results())
    selectResult('dc)
    mtxP = outfile("/home/mseminario2/vestarv/implementations/asic/castalia/analog/data/raw/px_hg_dc__ss75.meta" "w")
    fprintf(mtxP "sweep %%L\n" car(errset(sweepNames())))
    close(mtxP)
    errset(mtxDump("/home/mseminario2/vestarv/implementations/asic/castalia/analog/data/raw/px_hg_dc__ss75__grid_rf.csv" VAR("rf")))
    errset(mtxDump("/home/mseminario2/vestarv/implementations/asic/castalia/analog/data/raw/px_hg_dc__ss75__ierr_0.csv" value((((VS("/V_OUT") - VAR("V_CM")) / VAR("rf")) - xval(((VS("/V_OUT") - VAR("V_CM")) / VAR("rf")))) 0)))
    errset(mtxDump("/home/mseminario2/vestarv/implementations/asic/castalia/analog/data/raw/px_hg_dc__ss75__ierr_lsb_max.csv" ymax(abs(clip((((((VS("/V_OUT") - VAR("V_CM")) / VAR("rf")) - xval(((VS("/V_OUT") - VAR("V_CM")) / VAR("rf")))) * VAR("rf")) / 0.002441) (0 - (1.155 / VAR("rf"))) (1.155 / VAR("rf")))))))
    errset(mtxDump("/home/mseminario2/vestarv/implementations/asic/castalia/analog/data/raw/px_hg_dc__ss75__slope_err_0.csv" (value(deriv(((VS("/V_OUT") - VAR("V_CM")) / VAR("rf"))) 0) - 1)))
  )
)

;; ---- corner 76 (pt76) / test px_hg_dc
when(isDir("/home/mseminario2/chips/castalia/ic/.simulation/castalia/tb_anatop_pixel/maestro/results/maestro/Interactive.20/76/ps_iacc_hg/psf")
  openResults("/home/mseminario2/chips/castalia/ic/.simulation/castalia/tb_anatop_pixel/maestro/results/maestro/Interactive.20/76/ps_iacc_hg/psf")
  when(member('dc results())
    selectResult('dc)
    mtxP = outfile("/home/mseminario2/vestarv/implementations/asic/castalia/analog/data/raw/px_hg_dc__pt76.meta" "w")
    fprintf(mtxP "sweep %%L\n" car(errset(sweepNames())))
    close(mtxP)
    errset(mtxDump("/home/mseminario2/vestarv/implementations/asic/castalia/analog/data/raw/px_hg_dc__pt76__grid_rf.csv" VAR("rf")))
    errset(mtxDump("/home/mseminario2/vestarv/implementations/asic/castalia/analog/data/raw/px_hg_dc__pt76__ierr_0.csv" value((((VS("/V_OUT") - VAR("V_CM")) / VAR("rf")) - xval(((VS("/V_OUT") - VAR("V_CM")) / VAR("rf")))) 0)))
    errset(mtxDump("/home/mseminario2/vestarv/implementations/asic/castalia/analog/data/raw/px_hg_dc__pt76__ierr_lsb_max.csv" ymax(abs(clip((((((VS("/V_OUT") - VAR("V_CM")) / VAR("rf")) - xval(((VS("/V_OUT") - VAR("V_CM")) / VAR("rf")))) * VAR("rf")) / 0.002441) (0 - (1.155 / VAR("rf"))) (1.155 / VAR("rf")))))))
    errset(mtxDump("/home/mseminario2/vestarv/implementations/asic/castalia/analog/data/raw/px_hg_dc__pt76__slope_err_0.csv" (value(deriv(((VS("/V_OUT") - VAR("V_CM")) / VAR("rf"))) 0) - 1)))
  )
)

;; ---- corner 77 (ff77) / test px_hg_dc
when(isDir("/home/mseminario2/chips/castalia/ic/.simulation/castalia/tb_anatop_pixel/maestro/results/maestro/Interactive.20/77/ps_iacc_hg/psf")
  openResults("/home/mseminario2/chips/castalia/ic/.simulation/castalia/tb_anatop_pixel/maestro/results/maestro/Interactive.20/77/ps_iacc_hg/psf")
  when(member('dc results())
    selectResult('dc)
    mtxP = outfile("/home/mseminario2/vestarv/implementations/asic/castalia/analog/data/raw/px_hg_dc__ff77.meta" "w")
    fprintf(mtxP "sweep %%L\n" car(errset(sweepNames())))
    close(mtxP)
    errset(mtxDump("/home/mseminario2/vestarv/implementations/asic/castalia/analog/data/raw/px_hg_dc__ff77__grid_rf.csv" VAR("rf")))
    errset(mtxDump("/home/mseminario2/vestarv/implementations/asic/castalia/analog/data/raw/px_hg_dc__ff77__ierr_0.csv" value((((VS("/V_OUT") - VAR("V_CM")) / VAR("rf")) - xval(((VS("/V_OUT") - VAR("V_CM")) / VAR("rf")))) 0)))
    errset(mtxDump("/home/mseminario2/vestarv/implementations/asic/castalia/analog/data/raw/px_hg_dc__ff77__ierr_lsb_max.csv" ymax(abs(clip((((((VS("/V_OUT") - VAR("V_CM")) / VAR("rf")) - xval(((VS("/V_OUT") - VAR("V_CM")) / VAR("rf")))) * VAR("rf")) / 0.002441) (0 - (1.155 / VAR("rf"))) (1.155 / VAR("rf")))))))
    errset(mtxDump("/home/mseminario2/vestarv/implementations/asic/castalia/analog/data/raw/px_hg_dc__ff77__slope_err_0.csv" (value(deriv(((VS("/V_OUT") - VAR("V_CM")) / VAR("rf"))) 0) - 1)))
  )
)

;; ---- corner 78 (fs78) / test px_hg_dc
when(isDir("/home/mseminario2/chips/castalia/ic/.simulation/castalia/tb_anatop_pixel/maestro/results/maestro/Interactive.20/78/ps_iacc_hg/psf")
  openResults("/home/mseminario2/chips/castalia/ic/.simulation/castalia/tb_anatop_pixel/maestro/results/maestro/Interactive.20/78/ps_iacc_hg/psf")
  when(member('dc results())
    selectResult('dc)
    mtxP = outfile("/home/mseminario2/vestarv/implementations/asic/castalia/analog/data/raw/px_hg_dc__fs78.meta" "w")
    fprintf(mtxP "sweep %%L\n" car(errset(sweepNames())))
    close(mtxP)
    errset(mtxDump("/home/mseminario2/vestarv/implementations/asic/castalia/analog/data/raw/px_hg_dc__fs78__grid_rf.csv" VAR("rf")))
    errset(mtxDump("/home/mseminario2/vestarv/implementations/asic/castalia/analog/data/raw/px_hg_dc__fs78__ierr_0.csv" value((((VS("/V_OUT") - VAR("V_CM")) / VAR("rf")) - xval(((VS("/V_OUT") - VAR("V_CM")) / VAR("rf")))) 0)))
    errset(mtxDump("/home/mseminario2/vestarv/implementations/asic/castalia/analog/data/raw/px_hg_dc__fs78__ierr_lsb_max.csv" ymax(abs(clip((((((VS("/V_OUT") - VAR("V_CM")) / VAR("rf")) - xval(((VS("/V_OUT") - VAR("V_CM")) / VAR("rf")))) * VAR("rf")) / 0.002441) (0 - (1.155 / VAR("rf"))) (1.155 / VAR("rf")))))))
    errset(mtxDump("/home/mseminario2/vestarv/implementations/asic/castalia/analog/data/raw/px_hg_dc__fs78__slope_err_0.csv" (value(deriv(((VS("/V_OUT") - VAR("V_CM")) / VAR("rf"))) 0) - 1)))
  )
)

;; ---- corner 79 (sf79) / test px_hg_dc
when(isDir("/home/mseminario2/chips/castalia/ic/.simulation/castalia/tb_anatop_pixel/maestro/results/maestro/Interactive.20/79/ps_iacc_hg/psf")
  openResults("/home/mseminario2/chips/castalia/ic/.simulation/castalia/tb_anatop_pixel/maestro/results/maestro/Interactive.20/79/ps_iacc_hg/psf")
  when(member('dc results())
    selectResult('dc)
    mtxP = outfile("/home/mseminario2/vestarv/implementations/asic/castalia/analog/data/raw/px_hg_dc__sf79.meta" "w")
    fprintf(mtxP "sweep %%L\n" car(errset(sweepNames())))
    close(mtxP)
    errset(mtxDump("/home/mseminario2/vestarv/implementations/asic/castalia/analog/data/raw/px_hg_dc__sf79__grid_rf.csv" VAR("rf")))
    errset(mtxDump("/home/mseminario2/vestarv/implementations/asic/castalia/analog/data/raw/px_hg_dc__sf79__ierr_0.csv" value((((VS("/V_OUT") - VAR("V_CM")) / VAR("rf")) - xval(((VS("/V_OUT") - VAR("V_CM")) / VAR("rf")))) 0)))
    errset(mtxDump("/home/mseminario2/vestarv/implementations/asic/castalia/analog/data/raw/px_hg_dc__sf79__ierr_lsb_max.csv" ymax(abs(clip((((((VS("/V_OUT") - VAR("V_CM")) / VAR("rf")) - xval(((VS("/V_OUT") - VAR("V_CM")) / VAR("rf")))) * VAR("rf")) / 0.002441) (0 - (1.155 / VAR("rf"))) (1.155 / VAR("rf")))))))
    errset(mtxDump("/home/mseminario2/vestarv/implementations/asic/castalia/analog/data/raw/px_hg_dc__sf79__slope_err_0.csv" (value(deriv(((VS("/V_OUT") - VAR("V_CM")) / VAR("rf"))) 0) - 1)))
  )
)

;; ---- corner 80 (ss80) / test px_hg_dc
when(isDir("/home/mseminario2/chips/castalia/ic/.simulation/castalia/tb_anatop_pixel/maestro/results/maestro/Interactive.20/80/ps_iacc_hg/psf")
  openResults("/home/mseminario2/chips/castalia/ic/.simulation/castalia/tb_anatop_pixel/maestro/results/maestro/Interactive.20/80/ps_iacc_hg/psf")
  when(member('dc results())
    selectResult('dc)
    mtxP = outfile("/home/mseminario2/vestarv/implementations/asic/castalia/analog/data/raw/px_hg_dc__ss80.meta" "w")
    fprintf(mtxP "sweep %%L\n" car(errset(sweepNames())))
    close(mtxP)
    errset(mtxDump("/home/mseminario2/vestarv/implementations/asic/castalia/analog/data/raw/px_hg_dc__ss80__grid_rf.csv" VAR("rf")))
    errset(mtxDump("/home/mseminario2/vestarv/implementations/asic/castalia/analog/data/raw/px_hg_dc__ss80__ierr_0.csv" value((((VS("/V_OUT") - VAR("V_CM")) / VAR("rf")) - xval(((VS("/V_OUT") - VAR("V_CM")) / VAR("rf")))) 0)))
    errset(mtxDump("/home/mseminario2/vestarv/implementations/asic/castalia/analog/data/raw/px_hg_dc__ss80__ierr_lsb_max.csv" ymax(abs(clip((((((VS("/V_OUT") - VAR("V_CM")) / VAR("rf")) - xval(((VS("/V_OUT") - VAR("V_CM")) / VAR("rf")))) * VAR("rf")) / 0.002441) (0 - (1.155 / VAR("rf"))) (1.155 / VAR("rf")))))))
    errset(mtxDump("/home/mseminario2/vestarv/implementations/asic/castalia/analog/data/raw/px_hg_dc__ss80__slope_err_0.csv" (value(deriv(((VS("/V_OUT") - VAR("V_CM")) / VAR("rf"))) 0) - 1)))
  )
)

printf("MTX_EXTRACT_DONE\n")
exit(0)
